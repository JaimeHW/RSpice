// Canonical three-electrical-terminal VBIC 1.3 variant.
// The model equations remain in the upstream vbic_1p3.va source.
`define threeTerminal
`include "vbic_1p3.va"
