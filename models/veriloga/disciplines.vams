// Standard Verilog-AMS Disciplines
// Based on IEEE Std 1800-2017 and Verilog-A LRM 2.4

`ifdef DISCIPLINES_VAMS
`else
`define DISCIPLINES_VAMS 1

// Nature declarations for electrical discipline
nature Current;
    units = "A";
    access = I;
    idt_nature = Charge;
    abstol = 1e-12;
endnature

nature Charge;
    units = "coul";
    access = Q;
    ddt_nature = Current;
    abstol = 1e-14;
endnature

nature Voltage;
    units = "V";
    access = V;
    idt_nature = Flux;
    abstol = 1e-6;
endnature

nature Flux;
    units = "Wb";
    access = Phi;
    ddt_nature = Voltage;
    abstol = 1e-9;
endnature

// Electrical discipline (most common)
discipline electrical;
    potential Voltage;
    flow Current;
enddiscipline

discipline voltage;
    potential Voltage;
enddiscipline

discipline current;
    flow Current;
enddiscipline

// Magnetic discipline
discipline magnetic;
    potential Flux;
    flow Current;
enddiscipline

// Thermal disciplines
nature Temperature;
    units = "K";
    access = Temp;
    abstol = 1e-4;
endnature

nature Power;
    units = "W";
    access = Pwr;
    abstol = 1e-9;
endnature

discipline thermal;
    potential Temperature;
    flow Power;
enddiscipline

// Rotational mechanical disciplines
nature Angle;
    units = "rad";
    access = Theta;
    abstol = 1e-6;
endnature

nature Angular_Velocity;
    units = "rad/s";
    access = Omega;
    abstol = 1e-6;
endnature

nature Angular_Force;
    units = "N*m";
    access = Tau;
    abstol = 1e-6;
endnature

discipline rotational;
    potential Angle;
    flow Angular_Force;
enddiscipline

discipline rotational_omega;
    potential Angular_Velocity;
    flow Angular_Force;
enddiscipline

// Kinematic disciplines
nature Position;
    units = "m";
    access = x;
    abstol = 1e-6;
endnature

nature Velocity;
    units = "m/s";
    access = v;
    abstol = 1e-6;
endnature

nature Force;
    units = "N";
    access = F;
    abstol = 1e-6;
endnature

nature Acceleration;
    units = "m/s^2";
    access = a;
    abstol = 1e-6;
endnature

discipline kinematic;
    potential Position;
    flow Force;
enddiscipline

discipline kinematic_v;
    potential Velocity;
    flow Force;
enddiscipline

`endif
