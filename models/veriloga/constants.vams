// Standard Verilog-AMS Physical Constants
// Based on IEEE Std 1800-2017 and NIST CODATA 2018 values

`ifdef CONSTANTS_VAMS
`else
`define CONSTANTS_VAMS 1

// Mathematical constants
`define M_E         2.7182818284590452354
`define M_LOG2E     1.4426950408889634074
`define M_LOG10E    0.43429448190325182765
`define M_LN2       0.69314718055994530942
`define M_LN10      2.30258509299404568402
`define M_PI        3.14159265358979323846
`define M_TWO_PI    6.28318530717958647692
`define M_PI_2      1.57079632679489661923
`define M_PI_4      0.78539816339744830962
`define M_1_PI      0.31830988618379067154
`define M_2_PI      0.63661977236758134308
`define M_2_SQRTPI  1.12837916709551257390
`define M_SQRT2     1.41421356237309504880
`define M_SQRT1_2   0.70710678118654752440

// Physical constants (CODATA 2018)
// Elementary charge (C)
`define P_Q         1.602176634e-19
// Speed of light (m/s)
`define P_C         2.99792458e8
// Boltzmann constant (J/K)
`define P_K         1.380649e-23
// Planck constant (J*s)
`define P_H         6.62607015e-34
// Vacuum permittivity (F/m)
`define P_EPS0      8.8541878128e-12
// Vacuum permeability (H/m)
`define P_MU0       1.25663706212e-6
// Celsius to Kelvin offset
`define P_CELSIUSOFFSET 273.15
`define P_CELSIUS0      273.15

// Legacy compact-model aliases from older constants.vams revisions
`define P_Q_NIST1998 1.602176462e-19
`define P_K_NIST1998 1.3806503e-23

// Semiconductor constants
// Avogadro's number (1/mol)
`define P_N_AVOGADRO  6.02214076e23
// Si bandgap at 300K (eV)
`define P_EG_SI     1.12
// Si intrinsic carrier conc at 300K (1/cm^3)
`define P_NI_SI     1.45e10

// Verilog-A specific (common usage in compact models)
// exp() limiting threshold
`define EXPL_THRESHOLD  80.0
`define EXP_THRESHOLD   80.0
// exp(80)
`define MAX_EXPL        5.540622384e+34
`define MAX_EXP         5.540622384e+34
// exp(-80)
`define MIN_EXPL        1.804851387e-35
`define MIN_EXP         1.804851387e-35
// Minimum for log()
`define N_MINLOG        1.0e-38
`define DELTA_1         0.02
`define DELTA_2         0.02
`define DELTA_3         0.02
`define DELTA_4         0.02

`endif
