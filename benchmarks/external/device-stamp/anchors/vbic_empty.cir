* VBIC anchor (empty): 200 devices, generated by run.sh
.options acct
vb 1 0 dc 0.8
vc 2 0 dc 2.0
r1 2 1 1meg
r2 2 1 1meg
r3 2 1 1meg
r4 2 1 1meg
r5 2 1 1meg
r6 2 1 1meg
r7 2 1 1meg
r8 2 1 1meg
r9 2 1 1meg
r10 2 1 1meg
r11 2 1 1meg
r12 2 1 1meg
r13 2 1 1meg
r14 2 1 1meg
r15 2 1 1meg
r16 2 1 1meg
r17 2 1 1meg
r18 2 1 1meg
r19 2 1 1meg
r20 2 1 1meg
r21 2 1 1meg
r22 2 1 1meg
r23 2 1 1meg
r24 2 1 1meg
r25 2 1 1meg
r26 2 1 1meg
r27 2 1 1meg
r28 2 1 1meg
r29 2 1 1meg
r30 2 1 1meg
r31 2 1 1meg
r32 2 1 1meg
r33 2 1 1meg
r34 2 1 1meg
r35 2 1 1meg
r36 2 1 1meg
r37 2 1 1meg
r38 2 1 1meg
r39 2 1 1meg
r40 2 1 1meg
r41 2 1 1meg
r42 2 1 1meg
r43 2 1 1meg
r44 2 1 1meg
r45 2 1 1meg
r46 2 1 1meg
r47 2 1 1meg
r48 2 1 1meg
r49 2 1 1meg
r50 2 1 1meg
r51 2 1 1meg
r52 2 1 1meg
r53 2 1 1meg
r54 2 1 1meg
r55 2 1 1meg
r56 2 1 1meg
r57 2 1 1meg
r58 2 1 1meg
r59 2 1 1meg
r60 2 1 1meg
r61 2 1 1meg
r62 2 1 1meg
r63 2 1 1meg
r64 2 1 1meg
r65 2 1 1meg
r66 2 1 1meg
r67 2 1 1meg
r68 2 1 1meg
r69 2 1 1meg
r70 2 1 1meg
r71 2 1 1meg
r72 2 1 1meg
r73 2 1 1meg
r74 2 1 1meg
r75 2 1 1meg
r76 2 1 1meg
r77 2 1 1meg
r78 2 1 1meg
r79 2 1 1meg
r80 2 1 1meg
r81 2 1 1meg
r82 2 1 1meg
r83 2 1 1meg
r84 2 1 1meg
r85 2 1 1meg
r86 2 1 1meg
r87 2 1 1meg
r88 2 1 1meg
r89 2 1 1meg
r90 2 1 1meg
r91 2 1 1meg
r92 2 1 1meg
r93 2 1 1meg
r94 2 1 1meg
r95 2 1 1meg
r96 2 1 1meg
r97 2 1 1meg
r98 2 1 1meg
r99 2 1 1meg
r100 2 1 1meg
r101 2 1 1meg
r102 2 1 1meg
r103 2 1 1meg
r104 2 1 1meg
r105 2 1 1meg
r106 2 1 1meg
r107 2 1 1meg
r108 2 1 1meg
r109 2 1 1meg
r110 2 1 1meg
r111 2 1 1meg
r112 2 1 1meg
r113 2 1 1meg
r114 2 1 1meg
r115 2 1 1meg
r116 2 1 1meg
r117 2 1 1meg
r118 2 1 1meg
r119 2 1 1meg
r120 2 1 1meg
r121 2 1 1meg
r122 2 1 1meg
r123 2 1 1meg
r124 2 1 1meg
r125 2 1 1meg
r126 2 1 1meg
r127 2 1 1meg
r128 2 1 1meg
r129 2 1 1meg
r130 2 1 1meg
r131 2 1 1meg
r132 2 1 1meg
r133 2 1 1meg
r134 2 1 1meg
r135 2 1 1meg
r136 2 1 1meg
r137 2 1 1meg
r138 2 1 1meg
r139 2 1 1meg
r140 2 1 1meg
r141 2 1 1meg
r142 2 1 1meg
r143 2 1 1meg
r144 2 1 1meg
r145 2 1 1meg
r146 2 1 1meg
r147 2 1 1meg
r148 2 1 1meg
r149 2 1 1meg
r150 2 1 1meg
r151 2 1 1meg
r152 2 1 1meg
r153 2 1 1meg
r154 2 1 1meg
r155 2 1 1meg
r156 2 1 1meg
r157 2 1 1meg
r158 2 1 1meg
r159 2 1 1meg
r160 2 1 1meg
r161 2 1 1meg
r162 2 1 1meg
r163 2 1 1meg
r164 2 1 1meg
r165 2 1 1meg
r166 2 1 1meg
r167 2 1 1meg
r168 2 1 1meg
r169 2 1 1meg
r170 2 1 1meg
r171 2 1 1meg
r172 2 1 1meg
r173 2 1 1meg
r174 2 1 1meg
r175 2 1 1meg
r176 2 1 1meg
r177 2 1 1meg
r178 2 1 1meg
r179 2 1 1meg
r180 2 1 1meg
r181 2 1 1meg
r182 2 1 1meg
r183 2 1 1meg
r184 2 1 1meg
r185 2 1 1meg
r186 2 1 1meg
r187 2 1 1meg
r188 2 1 1meg
r189 2 1 1meg
r190 2 1 1meg
r191 2 1 1meg
r192 2 1 1meg
r193 2 1 1meg
r194 2 1 1meg
r195 2 1 1meg
r196 2 1 1meg
r197 2 1 1meg
r198 2 1 1meg
r199 2 1 1meg
r200 2 1 1meg
.model qmod npn level=4
.dc vb 0.5 0.9 0.002000
.print dc i(vc)
.end
