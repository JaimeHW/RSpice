* rc_ladder_100 -- 100-section RC ladder, PULSE-driven transient benchmark
* GENERATED by `rspice-bench gen`; do not edit by hand -- regenerate instead.
VIN in 0 DC 0 PULSE(0 1 0 1n 1n 99n 200n)
R1 in n1 100
C1 n1 0 1p
R2 n1 n2 100
C2 n2 0 1p
R3 n2 n3 100
C3 n3 0 1p
R4 n3 n4 100
C4 n4 0 1p
R5 n4 n5 100
C5 n5 0 1p
R6 n5 n6 100
C6 n6 0 1p
R7 n6 n7 100
C7 n7 0 1p
R8 n7 n8 100
C8 n8 0 1p
R9 n8 n9 100
C9 n9 0 1p
R10 n9 n10 100
C10 n10 0 1p
R11 n10 n11 100
C11 n11 0 1p
R12 n11 n12 100
C12 n12 0 1p
R13 n12 n13 100
C13 n13 0 1p
R14 n13 n14 100
C14 n14 0 1p
R15 n14 n15 100
C15 n15 0 1p
R16 n15 n16 100
C16 n16 0 1p
R17 n16 n17 100
C17 n17 0 1p
R18 n17 n18 100
C18 n18 0 1p
R19 n18 n19 100
C19 n19 0 1p
R20 n19 n20 100
C20 n20 0 1p
R21 n20 n21 100
C21 n21 0 1p
R22 n21 n22 100
C22 n22 0 1p
R23 n22 n23 100
C23 n23 0 1p
R24 n23 n24 100
C24 n24 0 1p
R25 n24 n25 100
C25 n25 0 1p
R26 n25 n26 100
C26 n26 0 1p
R27 n26 n27 100
C27 n27 0 1p
R28 n27 n28 100
C28 n28 0 1p
R29 n28 n29 100
C29 n29 0 1p
R30 n29 n30 100
C30 n30 0 1p
R31 n30 n31 100
C31 n31 0 1p
R32 n31 n32 100
C32 n32 0 1p
R33 n32 n33 100
C33 n33 0 1p
R34 n33 n34 100
C34 n34 0 1p
R35 n34 n35 100
C35 n35 0 1p
R36 n35 n36 100
C36 n36 0 1p
R37 n36 n37 100
C37 n37 0 1p
R38 n37 n38 100
C38 n38 0 1p
R39 n38 n39 100
C39 n39 0 1p
R40 n39 n40 100
C40 n40 0 1p
R41 n40 n41 100
C41 n41 0 1p
R42 n41 n42 100
C42 n42 0 1p
R43 n42 n43 100
C43 n43 0 1p
R44 n43 n44 100
C44 n44 0 1p
R45 n44 n45 100
C45 n45 0 1p
R46 n45 n46 100
C46 n46 0 1p
R47 n46 n47 100
C47 n47 0 1p
R48 n47 n48 100
C48 n48 0 1p
R49 n48 n49 100
C49 n49 0 1p
R50 n49 n50 100
C50 n50 0 1p
R51 n50 n51 100
C51 n51 0 1p
R52 n51 n52 100
C52 n52 0 1p
R53 n52 n53 100
C53 n53 0 1p
R54 n53 n54 100
C54 n54 0 1p
R55 n54 n55 100
C55 n55 0 1p
R56 n55 n56 100
C56 n56 0 1p
R57 n56 n57 100
C57 n57 0 1p
R58 n57 n58 100
C58 n58 0 1p
R59 n58 n59 100
C59 n59 0 1p
R60 n59 n60 100
C60 n60 0 1p
R61 n60 n61 100
C61 n61 0 1p
R62 n61 n62 100
C62 n62 0 1p
R63 n62 n63 100
C63 n63 0 1p
R64 n63 n64 100
C64 n64 0 1p
R65 n64 n65 100
C65 n65 0 1p
R66 n65 n66 100
C66 n66 0 1p
R67 n66 n67 100
C67 n67 0 1p
R68 n67 n68 100
C68 n68 0 1p
R69 n68 n69 100
C69 n69 0 1p
R70 n69 n70 100
C70 n70 0 1p
R71 n70 n71 100
C71 n71 0 1p
R72 n71 n72 100
C72 n72 0 1p
R73 n72 n73 100
C73 n73 0 1p
R74 n73 n74 100
C74 n74 0 1p
R75 n74 n75 100
C75 n75 0 1p
R76 n75 n76 100
C76 n76 0 1p
R77 n76 n77 100
C77 n77 0 1p
R78 n77 n78 100
C78 n78 0 1p
R79 n78 n79 100
C79 n79 0 1p
R80 n79 n80 100
C80 n80 0 1p
R81 n80 n81 100
C81 n81 0 1p
R82 n81 n82 100
C82 n82 0 1p
R83 n82 n83 100
C83 n83 0 1p
R84 n83 n84 100
C84 n84 0 1p
R85 n84 n85 100
C85 n85 0 1p
R86 n85 n86 100
C86 n86 0 1p
R87 n86 n87 100
C87 n87 0 1p
R88 n87 n88 100
C88 n88 0 1p
R89 n88 n89 100
C89 n89 0 1p
R90 n89 n90 100
C90 n90 0 1p
R91 n90 n91 100
C91 n91 0 1p
R92 n91 n92 100
C92 n92 0 1p
R93 n92 n93 100
C93 n93 0 1p
R94 n93 n94 100
C94 n94 0 1p
R95 n94 n95 100
C95 n95 0 1p
R96 n95 n96 100
C96 n96 0 1p
R97 n96 n97 100
C97 n97 0 1p
R98 n97 n98 100
C98 n98 0 1p
R99 n98 n99 100
C99 n99 0 1p
R100 n99 n100 100
C100 n100 0 1p
.options noacct
.tran 100p 1u
.print tran v(n100)
.end
