* VBIC anchor (loaded): 200 devices, generated by run.sh
.options acct
vb 1 0 dc 0.8
vc 2 0 dc 2.0
q1 2 1 0 qmod
q2 2 1 0 qmod
q3 2 1 0 qmod
q4 2 1 0 qmod
q5 2 1 0 qmod
q6 2 1 0 qmod
q7 2 1 0 qmod
q8 2 1 0 qmod
q9 2 1 0 qmod
q10 2 1 0 qmod
q11 2 1 0 qmod
q12 2 1 0 qmod
q13 2 1 0 qmod
q14 2 1 0 qmod
q15 2 1 0 qmod
q16 2 1 0 qmod
q17 2 1 0 qmod
q18 2 1 0 qmod
q19 2 1 0 qmod
q20 2 1 0 qmod
q21 2 1 0 qmod
q22 2 1 0 qmod
q23 2 1 0 qmod
q24 2 1 0 qmod
q25 2 1 0 qmod
q26 2 1 0 qmod
q27 2 1 0 qmod
q28 2 1 0 qmod
q29 2 1 0 qmod
q30 2 1 0 qmod
q31 2 1 0 qmod
q32 2 1 0 qmod
q33 2 1 0 qmod
q34 2 1 0 qmod
q35 2 1 0 qmod
q36 2 1 0 qmod
q37 2 1 0 qmod
q38 2 1 0 qmod
q39 2 1 0 qmod
q40 2 1 0 qmod
q41 2 1 0 qmod
q42 2 1 0 qmod
q43 2 1 0 qmod
q44 2 1 0 qmod
q45 2 1 0 qmod
q46 2 1 0 qmod
q47 2 1 0 qmod
q48 2 1 0 qmod
q49 2 1 0 qmod
q50 2 1 0 qmod
q51 2 1 0 qmod
q52 2 1 0 qmod
q53 2 1 0 qmod
q54 2 1 0 qmod
q55 2 1 0 qmod
q56 2 1 0 qmod
q57 2 1 0 qmod
q58 2 1 0 qmod
q59 2 1 0 qmod
q60 2 1 0 qmod
q61 2 1 0 qmod
q62 2 1 0 qmod
q63 2 1 0 qmod
q64 2 1 0 qmod
q65 2 1 0 qmod
q66 2 1 0 qmod
q67 2 1 0 qmod
q68 2 1 0 qmod
q69 2 1 0 qmod
q70 2 1 0 qmod
q71 2 1 0 qmod
q72 2 1 0 qmod
q73 2 1 0 qmod
q74 2 1 0 qmod
q75 2 1 0 qmod
q76 2 1 0 qmod
q77 2 1 0 qmod
q78 2 1 0 qmod
q79 2 1 0 qmod
q80 2 1 0 qmod
q81 2 1 0 qmod
q82 2 1 0 qmod
q83 2 1 0 qmod
q84 2 1 0 qmod
q85 2 1 0 qmod
q86 2 1 0 qmod
q87 2 1 0 qmod
q88 2 1 0 qmod
q89 2 1 0 qmod
q90 2 1 0 qmod
q91 2 1 0 qmod
q92 2 1 0 qmod
q93 2 1 0 qmod
q94 2 1 0 qmod
q95 2 1 0 qmod
q96 2 1 0 qmod
q97 2 1 0 qmod
q98 2 1 0 qmod
q99 2 1 0 qmod
q100 2 1 0 qmod
q101 2 1 0 qmod
q102 2 1 0 qmod
q103 2 1 0 qmod
q104 2 1 0 qmod
q105 2 1 0 qmod
q106 2 1 0 qmod
q107 2 1 0 qmod
q108 2 1 0 qmod
q109 2 1 0 qmod
q110 2 1 0 qmod
q111 2 1 0 qmod
q112 2 1 0 qmod
q113 2 1 0 qmod
q114 2 1 0 qmod
q115 2 1 0 qmod
q116 2 1 0 qmod
q117 2 1 0 qmod
q118 2 1 0 qmod
q119 2 1 0 qmod
q120 2 1 0 qmod
q121 2 1 0 qmod
q122 2 1 0 qmod
q123 2 1 0 qmod
q124 2 1 0 qmod
q125 2 1 0 qmod
q126 2 1 0 qmod
q127 2 1 0 qmod
q128 2 1 0 qmod
q129 2 1 0 qmod
q130 2 1 0 qmod
q131 2 1 0 qmod
q132 2 1 0 qmod
q133 2 1 0 qmod
q134 2 1 0 qmod
q135 2 1 0 qmod
q136 2 1 0 qmod
q137 2 1 0 qmod
q138 2 1 0 qmod
q139 2 1 0 qmod
q140 2 1 0 qmod
q141 2 1 0 qmod
q142 2 1 0 qmod
q143 2 1 0 qmod
q144 2 1 0 qmod
q145 2 1 0 qmod
q146 2 1 0 qmod
q147 2 1 0 qmod
q148 2 1 0 qmod
q149 2 1 0 qmod
q150 2 1 0 qmod
q151 2 1 0 qmod
q152 2 1 0 qmod
q153 2 1 0 qmod
q154 2 1 0 qmod
q155 2 1 0 qmod
q156 2 1 0 qmod
q157 2 1 0 qmod
q158 2 1 0 qmod
q159 2 1 0 qmod
q160 2 1 0 qmod
q161 2 1 0 qmod
q162 2 1 0 qmod
q163 2 1 0 qmod
q164 2 1 0 qmod
q165 2 1 0 qmod
q166 2 1 0 qmod
q167 2 1 0 qmod
q168 2 1 0 qmod
q169 2 1 0 qmod
q170 2 1 0 qmod
q171 2 1 0 qmod
q172 2 1 0 qmod
q173 2 1 0 qmod
q174 2 1 0 qmod
q175 2 1 0 qmod
q176 2 1 0 qmod
q177 2 1 0 qmod
q178 2 1 0 qmod
q179 2 1 0 qmod
q180 2 1 0 qmod
q181 2 1 0 qmod
q182 2 1 0 qmod
q183 2 1 0 qmod
q184 2 1 0 qmod
q185 2 1 0 qmod
q186 2 1 0 qmod
q187 2 1 0 qmod
q188 2 1 0 qmod
q189 2 1 0 qmod
q190 2 1 0 qmod
q191 2 1 0 qmod
q192 2 1 0 qmod
q193 2 1 0 qmod
q194 2 1 0 qmod
q195 2 1 0 qmod
q196 2 1 0 qmod
q197 2 1 0 qmod
q198 2 1 0 qmod
q199 2 1 0 qmod
q200 2 1 0 qmod
.model qmod npn level=4
.dc vb 0.5 0.9 0.002000
.print dc i(vc)
.end
