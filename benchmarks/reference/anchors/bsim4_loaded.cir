* BSIM4 anchor (loaded): 200 devices, generated by run.sh
.options acct
vg 1 0 dc 1.0
vd 2 0 dc 1.0
m1 2 1 0 0 nmod w=1u l=45n
m2 2 1 0 0 nmod w=1u l=45n
m3 2 1 0 0 nmod w=1u l=45n
m4 2 1 0 0 nmod w=1u l=45n
m5 2 1 0 0 nmod w=1u l=45n
m6 2 1 0 0 nmod w=1u l=45n
m7 2 1 0 0 nmod w=1u l=45n
m8 2 1 0 0 nmod w=1u l=45n
m9 2 1 0 0 nmod w=1u l=45n
m10 2 1 0 0 nmod w=1u l=45n
m11 2 1 0 0 nmod w=1u l=45n
m12 2 1 0 0 nmod w=1u l=45n
m13 2 1 0 0 nmod w=1u l=45n
m14 2 1 0 0 nmod w=1u l=45n
m15 2 1 0 0 nmod w=1u l=45n
m16 2 1 0 0 nmod w=1u l=45n
m17 2 1 0 0 nmod w=1u l=45n
m18 2 1 0 0 nmod w=1u l=45n
m19 2 1 0 0 nmod w=1u l=45n
m20 2 1 0 0 nmod w=1u l=45n
m21 2 1 0 0 nmod w=1u l=45n
m22 2 1 0 0 nmod w=1u l=45n
m23 2 1 0 0 nmod w=1u l=45n
m24 2 1 0 0 nmod w=1u l=45n
m25 2 1 0 0 nmod w=1u l=45n
m26 2 1 0 0 nmod w=1u l=45n
m27 2 1 0 0 nmod w=1u l=45n
m28 2 1 0 0 nmod w=1u l=45n
m29 2 1 0 0 nmod w=1u l=45n
m30 2 1 0 0 nmod w=1u l=45n
m31 2 1 0 0 nmod w=1u l=45n
m32 2 1 0 0 nmod w=1u l=45n
m33 2 1 0 0 nmod w=1u l=45n
m34 2 1 0 0 nmod w=1u l=45n
m35 2 1 0 0 nmod w=1u l=45n
m36 2 1 0 0 nmod w=1u l=45n
m37 2 1 0 0 nmod w=1u l=45n
m38 2 1 0 0 nmod w=1u l=45n
m39 2 1 0 0 nmod w=1u l=45n
m40 2 1 0 0 nmod w=1u l=45n
m41 2 1 0 0 nmod w=1u l=45n
m42 2 1 0 0 nmod w=1u l=45n
m43 2 1 0 0 nmod w=1u l=45n
m44 2 1 0 0 nmod w=1u l=45n
m45 2 1 0 0 nmod w=1u l=45n
m46 2 1 0 0 nmod w=1u l=45n
m47 2 1 0 0 nmod w=1u l=45n
m48 2 1 0 0 nmod w=1u l=45n
m49 2 1 0 0 nmod w=1u l=45n
m50 2 1 0 0 nmod w=1u l=45n
m51 2 1 0 0 nmod w=1u l=45n
m52 2 1 0 0 nmod w=1u l=45n
m53 2 1 0 0 nmod w=1u l=45n
m54 2 1 0 0 nmod w=1u l=45n
m55 2 1 0 0 nmod w=1u l=45n
m56 2 1 0 0 nmod w=1u l=45n
m57 2 1 0 0 nmod w=1u l=45n
m58 2 1 0 0 nmod w=1u l=45n
m59 2 1 0 0 nmod w=1u l=45n
m60 2 1 0 0 nmod w=1u l=45n
m61 2 1 0 0 nmod w=1u l=45n
m62 2 1 0 0 nmod w=1u l=45n
m63 2 1 0 0 nmod w=1u l=45n
m64 2 1 0 0 nmod w=1u l=45n
m65 2 1 0 0 nmod w=1u l=45n
m66 2 1 0 0 nmod w=1u l=45n
m67 2 1 0 0 nmod w=1u l=45n
m68 2 1 0 0 nmod w=1u l=45n
m69 2 1 0 0 nmod w=1u l=45n
m70 2 1 0 0 nmod w=1u l=45n
m71 2 1 0 0 nmod w=1u l=45n
m72 2 1 0 0 nmod w=1u l=45n
m73 2 1 0 0 nmod w=1u l=45n
m74 2 1 0 0 nmod w=1u l=45n
m75 2 1 0 0 nmod w=1u l=45n
m76 2 1 0 0 nmod w=1u l=45n
m77 2 1 0 0 nmod w=1u l=45n
m78 2 1 0 0 nmod w=1u l=45n
m79 2 1 0 0 nmod w=1u l=45n
m80 2 1 0 0 nmod w=1u l=45n
m81 2 1 0 0 nmod w=1u l=45n
m82 2 1 0 0 nmod w=1u l=45n
m83 2 1 0 0 nmod w=1u l=45n
m84 2 1 0 0 nmod w=1u l=45n
m85 2 1 0 0 nmod w=1u l=45n
m86 2 1 0 0 nmod w=1u l=45n
m87 2 1 0 0 nmod w=1u l=45n
m88 2 1 0 0 nmod w=1u l=45n
m89 2 1 0 0 nmod w=1u l=45n
m90 2 1 0 0 nmod w=1u l=45n
m91 2 1 0 0 nmod w=1u l=45n
m92 2 1 0 0 nmod w=1u l=45n
m93 2 1 0 0 nmod w=1u l=45n
m94 2 1 0 0 nmod w=1u l=45n
m95 2 1 0 0 nmod w=1u l=45n
m96 2 1 0 0 nmod w=1u l=45n
m97 2 1 0 0 nmod w=1u l=45n
m98 2 1 0 0 nmod w=1u l=45n
m99 2 1 0 0 nmod w=1u l=45n
m100 2 1 0 0 nmod w=1u l=45n
m101 2 1 0 0 nmod w=1u l=45n
m102 2 1 0 0 nmod w=1u l=45n
m103 2 1 0 0 nmod w=1u l=45n
m104 2 1 0 0 nmod w=1u l=45n
m105 2 1 0 0 nmod w=1u l=45n
m106 2 1 0 0 nmod w=1u l=45n
m107 2 1 0 0 nmod w=1u l=45n
m108 2 1 0 0 nmod w=1u l=45n
m109 2 1 0 0 nmod w=1u l=45n
m110 2 1 0 0 nmod w=1u l=45n
m111 2 1 0 0 nmod w=1u l=45n
m112 2 1 0 0 nmod w=1u l=45n
m113 2 1 0 0 nmod w=1u l=45n
m114 2 1 0 0 nmod w=1u l=45n
m115 2 1 0 0 nmod w=1u l=45n
m116 2 1 0 0 nmod w=1u l=45n
m117 2 1 0 0 nmod w=1u l=45n
m118 2 1 0 0 nmod w=1u l=45n
m119 2 1 0 0 nmod w=1u l=45n
m120 2 1 0 0 nmod w=1u l=45n
m121 2 1 0 0 nmod w=1u l=45n
m122 2 1 0 0 nmod w=1u l=45n
m123 2 1 0 0 nmod w=1u l=45n
m124 2 1 0 0 nmod w=1u l=45n
m125 2 1 0 0 nmod w=1u l=45n
m126 2 1 0 0 nmod w=1u l=45n
m127 2 1 0 0 nmod w=1u l=45n
m128 2 1 0 0 nmod w=1u l=45n
m129 2 1 0 0 nmod w=1u l=45n
m130 2 1 0 0 nmod w=1u l=45n
m131 2 1 0 0 nmod w=1u l=45n
m132 2 1 0 0 nmod w=1u l=45n
m133 2 1 0 0 nmod w=1u l=45n
m134 2 1 0 0 nmod w=1u l=45n
m135 2 1 0 0 nmod w=1u l=45n
m136 2 1 0 0 nmod w=1u l=45n
m137 2 1 0 0 nmod w=1u l=45n
m138 2 1 0 0 nmod w=1u l=45n
m139 2 1 0 0 nmod w=1u l=45n
m140 2 1 0 0 nmod w=1u l=45n
m141 2 1 0 0 nmod w=1u l=45n
m142 2 1 0 0 nmod w=1u l=45n
m143 2 1 0 0 nmod w=1u l=45n
m144 2 1 0 0 nmod w=1u l=45n
m145 2 1 0 0 nmod w=1u l=45n
m146 2 1 0 0 nmod w=1u l=45n
m147 2 1 0 0 nmod w=1u l=45n
m148 2 1 0 0 nmod w=1u l=45n
m149 2 1 0 0 nmod w=1u l=45n
m150 2 1 0 0 nmod w=1u l=45n
m151 2 1 0 0 nmod w=1u l=45n
m152 2 1 0 0 nmod w=1u l=45n
m153 2 1 0 0 nmod w=1u l=45n
m154 2 1 0 0 nmod w=1u l=45n
m155 2 1 0 0 nmod w=1u l=45n
m156 2 1 0 0 nmod w=1u l=45n
m157 2 1 0 0 nmod w=1u l=45n
m158 2 1 0 0 nmod w=1u l=45n
m159 2 1 0 0 nmod w=1u l=45n
m160 2 1 0 0 nmod w=1u l=45n
m161 2 1 0 0 nmod w=1u l=45n
m162 2 1 0 0 nmod w=1u l=45n
m163 2 1 0 0 nmod w=1u l=45n
m164 2 1 0 0 nmod w=1u l=45n
m165 2 1 0 0 nmod w=1u l=45n
m166 2 1 0 0 nmod w=1u l=45n
m167 2 1 0 0 nmod w=1u l=45n
m168 2 1 0 0 nmod w=1u l=45n
m169 2 1 0 0 nmod w=1u l=45n
m170 2 1 0 0 nmod w=1u l=45n
m171 2 1 0 0 nmod w=1u l=45n
m172 2 1 0 0 nmod w=1u l=45n
m173 2 1 0 0 nmod w=1u l=45n
m174 2 1 0 0 nmod w=1u l=45n
m175 2 1 0 0 nmod w=1u l=45n
m176 2 1 0 0 nmod w=1u l=45n
m177 2 1 0 0 nmod w=1u l=45n
m178 2 1 0 0 nmod w=1u l=45n
m179 2 1 0 0 nmod w=1u l=45n
m180 2 1 0 0 nmod w=1u l=45n
m181 2 1 0 0 nmod w=1u l=45n
m182 2 1 0 0 nmod w=1u l=45n
m183 2 1 0 0 nmod w=1u l=45n
m184 2 1 0 0 nmod w=1u l=45n
m185 2 1 0 0 nmod w=1u l=45n
m186 2 1 0 0 nmod w=1u l=45n
m187 2 1 0 0 nmod w=1u l=45n
m188 2 1 0 0 nmod w=1u l=45n
m189 2 1 0 0 nmod w=1u l=45n
m190 2 1 0 0 nmod w=1u l=45n
m191 2 1 0 0 nmod w=1u l=45n
m192 2 1 0 0 nmod w=1u l=45n
m193 2 1 0 0 nmod w=1u l=45n
m194 2 1 0 0 nmod w=1u l=45n
m195 2 1 0 0 nmod w=1u l=45n
m196 2 1 0 0 nmod w=1u l=45n
m197 2 1 0 0 nmod w=1u l=45n
m198 2 1 0 0 nmod w=1u l=45n
m199 2 1 0 0 nmod w=1u l=45n
m200 2 1 0 0 nmod w=1u l=45n
.model nmod nmos level=14 version=4.8.2
.dc vg 0.2 1.0 0.004000
.print dc i(vd)
.end
