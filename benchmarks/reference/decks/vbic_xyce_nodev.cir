vbic dense-terminal device-eval microbenchmark
Vc c 0 2.0
Rdummy c 0 1e9
Vb b 0 0.7
Ve e 0 0.05
Vs s 0 0.02
.model N1 npn
+ level=11
+ IS=1e-16 IBEI=1e-18 IBEN=5e-15 IBCI=2e-17 IBCN=5e-15 ISP=1e-15 RCX=10
+ RCI=60 RBX=10 RBI=40 RE=2 RS=20 RBP=40 VEF=10 VER=4 IKF=2e-3 ITF=8e-2
+ XTF=20 IKR=2e-4 IKP=2e-4 CJE=1e-13 CJC=2e-14 CJEP=1e-13 CJCP=4e-13 VO=2
+ GAMM=2e-11 HRCF=2 QCO=1e-12 AVC1=2 AVC2=15 TF=10e-12 TR=100e-12 TD=2e-11 RTH=300
.dc Vb 0.3 0.9 0.00002
.print dc i(Vc)
.end
