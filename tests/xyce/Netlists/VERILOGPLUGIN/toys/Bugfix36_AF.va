// This is just a resistor with a completely unused analog function that
// tries to call a "$strobe".  Xyce/ADMS cannot currently allow that, but
// instead of crashing should just throw a warning and ignore the call.

`include "disciplines.vams"
`include "constants.vams"
// Xyce's K is not the one in constants.vams!
`define X_K (1.3806226e23)

(*xyceModelGroup="Resistor", xyceSpiceDeviceName="R", xyceLevelNumber="6"*)
module resistor (p,n);
   electrical p,n;
   inout p,n;

   (*desc="Resistance", type="instance"*) parameter real R=1 from (0:inf);

   real           Ir;
   real           tdevK;
   real           conductance;

   analog function real nugatory;
      input nada;
      real nada;

      begin

         $strobe("IZ IN UR FUNCTION STROBIN YOUR SHIZ");
         nugatory=nada;
      end
   endfunction

   analog
     begin
        tdevK=$temperature;
        conductance=1.0/R;
        Ir=V(p,n)*conductance;
        I(p,n) <+ Ir;
        I(p,n) <+ white_noise(4*`X_K*tdevK*conductance,"thermal");
     end
endmodule
