`include "disciplines.vams"
`include "constants.vams"

`define attr(txt) (*txt*)

module difftosingle (in1,in2,in3,in4,sel0,sel1,out);
     input in1, in2, in3, in4, sel0, sel1;
     electrical in1, in2, in3, in4, sel0, sel1;

     output out;
     electrical out;

     real result;
     real selection;

     analog begin
     // (A AND NOT S0 AND NOT S1) OR (B AND S0 AND NOT S1) OR (C AND NOT S0 AND S1) OR (D AND S0 AND S1)
          if (V(sel1) < 0.5)
               selection = V(sel0) > 0.5 ? 1 : 0;
          else
               selection = V(sel0) > 0.5 ? 3 : 2;

          case (selection)
               0: result = V(in1);
               1: result = V(in2);
               2: result = V(in3);
               3: result = V(in4);
          endcase

          V(out) <+ result;
     end
endmodule
