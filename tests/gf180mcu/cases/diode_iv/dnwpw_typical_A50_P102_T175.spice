GF180MCU dnwpw diode I-V, area=50um2 perim=102um, typical corner, 175C
* Rendered from models/ngspice/testing/regression/diode/device_netlists/iv.spice
* (GlobalFoundries PDK, Apache-2.0). Two deliberate departures from upstream:
* the `.control` block is replaced by an equivalent `.dc` card so the deck
* states its own analysis, and the sweep is taken from this device's measured
* bias points rather than the template's hardcoded np_3p3 range.
Vn n 0 dc 1
.temp 175
.options tnom=175
dn1 n 0 dnwpw AREA = 50p PJ = 102u
.dc Vn -20.21 1.21 0.21
.include "../../models/design.ngspice"
.lib "../../models/sm141064.ngspice" diode_typical
.end
