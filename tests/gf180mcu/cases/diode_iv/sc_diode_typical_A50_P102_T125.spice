GF180MCU sc_diode diode I-V, area=50um2 perim=102um, typical corner, 125C
* Rendered from models/ngspice/testing/regression/diode/device_netlists/iv.spice
* (GlobalFoundries PDK, Apache-2.0). Two deliberate departures from upstream:
* the `.control` block is replaced by an equivalent `.dc` card so the deck
* states its own analysis, and the sweep is taken from this device's measured
* bias points rather than the template's hardcoded np_3p3 range.
Vn n 0 dc 1
.temp 125
.options tnom=125
dn1 n 0 sc_diode AREA = 50p PJ = 102u
.dc Vn -25.26 1.26 0.26
.include "../../models/design.ngspice"
.lib "../../models/sm141064.ngspice" diode_typical
.end
