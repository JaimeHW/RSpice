// C12 testbench, variant oomr (RSpice-authored; corpus design C12): variant
// full, and at each reading it also reads the LDO's feedback node, which is
// inside the SPICE subcircuit xldo and no port of this module, with
// $cds_get_analog_value("xldo.fb") into fbk[k] and onto fbm (wreal).
`include "disciplines.vams"
`timescale 1ns/1ps
module tb_ldo(vout, sclk, sdi, csn, ok, meas, fbm);
  inout vout; electrical vout;
  output sclk, sdi, csn, ok; reg sclk, sdi, csn, ok;
  output meas; wreal meas;
  output fbm; wreal fbm;
  real mv, fv;
  real vk [0:15];
  real fbk [0:15];
  integer k, i;
  reg pass;
  assign meas = mv;
  assign fbm = fv;

  task load(input [3:0] code);
    begin
      csn = 1'b0;
      for (i = 3; i >= 0; i = i - 1) begin
        #500 sdi = code[i];
        #500 sclk = 1'b1;
        #500 sclk = 1'b0;
      end
      #500 csn = 1'b1;
    end
  endtask

  initial begin
    sclk = 1'b0; sdi = 1'b0; csn = 1'b1; ok = 1'b0; pass = 1'b1; mv = 0.0; fv = 0.0;
    for (k = 0; k < 16; k = k + 1) begin
      load(k);
      #92500 vk[k] = V(vout); mv = vk[k];
      fbk[k] = $cds_get_analog_value("xldo.fb"); fv = fbk[k];
      $display("code %0d: vout = %g V, fb = %g V", k, vk[k], fbk[k]);
      if (k > 0 && (vk[k] - vk[k-1] < 5e-3 || vk[k] - vk[k-1] > 20e-3)) begin
        pass = 1'b0;
        $error("code %0d: step %g V is outside [5 mV, 20 mV]", k, vk[k] - vk[k-1]);
      end
      #1000;
    end
    ok = pass;
    $finish;
  end
endmodule
