// C12 testbench, variant fail (RSpice-authored; corpus design C12): variant
// full with its step window narrowed to [5 mV, 7 mV]. Every step of the trim
// ladder (8.6 to 12.9 mV by the O5-O1 references) lies at least 1.6 mV above
// it, so each code from 1 to 15 is flagged with $error at line 40, 99 us into
// its 100 us slot, and ok stays 0. The run completes; its records are the
// checks the corpus compares.
//
`include "disciplines.vams"
`timescale 1ns/1ps
module tb_ldo(vout, sclk, sdi, csn, ok, meas);
  inout vout; electrical vout;
  output sclk, sdi, csn, ok; reg sclk, sdi, csn, ok;
  output meas; wreal meas;
  real mv;
  real vk [0:15];
  integer k, i;
  reg pass;
  assign meas = mv;

  task load(input [3:0] code);
    begin
      csn = 1'b0;
      for (i = 3; i >= 0; i = i - 1) begin
        #500 sdi = code[i];
        #500 sclk = 1'b1;
        #500 sclk = 1'b0;
      end
      #500 csn = 1'b1;
    end
  endtask

  initial begin
    sclk = 1'b0; sdi = 1'b0; csn = 1'b1; ok = 1'b0; pass = 1'b1; mv = 0.0;
    for (k = 0; k < 16; k = k + 1) begin
      load(k);
      #92500 vk[k] = V(vout); mv = vk[k];
      $display("code %0d: vout = %g V", k, vk[k]);
      if (k > 0 && (vk[k] - vk[k-1] < 5e-3 || vk[k] - vk[k-1] > 7e-3)) begin
        pass = 1'b0;
        $error("code %0d: step %g V is outside [5 mV, 7 mV]", k, vk[k] - vk[k-1]);
      end
      #1000;
    end
    ok = pass;
    $finish;
  end
endmodule
