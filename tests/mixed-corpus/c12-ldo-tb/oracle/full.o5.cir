* C12 variant full, held-digital O5 circuit (corpus O5 rules); the same circuit
* as oracle/unrolled.o5.cir: the trim register's D-A state (code 0) held at 0 V
* behind the built-in converters' 20 ohm, ok's initial 0 likewise; the
* testbench's real output meas held at its initial 0.0 V; the register, the
* testbench and their digital-only nets (sclk, sdi, csn) are removed. The
* runner appends the deck's analysis card.
.include ../../c05-ldo-trim/net/models-bsim4.cir
.include ../net/ldo_sub.cir
.include ../net/supply_load.cir
xldo vin vout tr3 tr2 tr1 tr0 ldo
vtr3 tr3_h 0 0
rtr3 tr3_h tr3 20
vtr2 tr2_h 0 0
rtr2 tr2_h tr2 20
vtr1 tr1_h 0 0
rtr1 tr1_h tr1 20
vtr0 tr0_h 0 0
rtr0 tr0_h tr0 20
vok ok_h 0 0
rok ok_h ok 20
vmeas meas 0 0
.end
