* C2 charge-pump PLL, variant mx, ac around the locked state at 25 us
.hdl "../net/vco_pwl.va"
.hdl "../net/div20_pfd.v"
.include ../net/pll-mx.cir
.include ../net/loopf_mx.cir
.include ../net/pll-models.cir
.param r1v=300 c1v=10n
.tran 0.1n 25u uic
.ac dec 3 1k 10meg actimes=25u
.end
