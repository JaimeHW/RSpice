* C2 charge-pump PLL, variant xs, pss
.include ../net/pll-xs.cir
.include ../net/vco_sub_new.cir
.include ../net/f-p-det-d-sub.cir
.include ../net/loop-filter-2.cir
.include ../net/pll-models.cir
.param r1v=300 c1v=10n
* Driven PSS: the 10 MHz reference clock (vref) sets the period; 20 us of
* settling first. The design's `.pss 10meg 20u` is ngspice's oscillator form,
* which also needs an oscillator node this driven loop does not have.
.pss fund=10meg tstab=20u
.end
