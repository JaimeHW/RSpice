* C2 charge-pump PLL, variant mx, pnoise
.hdl "../net/vco_pwl.va"
.hdl "../net/div20_pfd.v"
.include ../net/pll-mx.cir
.include ../net/loopf_mx.cir
.include ../net/pll-models.cir
.param r1v=300 c1v=10n
.pss 10meg 20u
.pnoise v(vco_out) dec 10 1k 10meg
.end
