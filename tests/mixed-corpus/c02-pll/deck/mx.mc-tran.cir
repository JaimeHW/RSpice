* C2 charge-pump PLL, variant mx, mc-tran
.hdl "../net/vco_pwl.va"
.hdl "../net/div20_pfd.v"
.include ../net/pll-mx.cir
.include ../net/loopf_mx.cir
.include ../net/pll-models.cir
.param r1v={agauss(300,15,1)} c1v={agauss(10n,0.5n,1)}
.mc 8 seed 11
.tran 0.1n 25u uic
.end
