// C9 variant live (RSpice-authored; corpus design C9, amendment A4b): the
// controller of net/por_ctrl.v unchanged, with its boundaries converted by the
// shipped a2d and d2a connect modules (verbatim), whose supply is named as the
// vdd net. A net-named vsup binds the built-in converters to that net live: a
// held 1 drives V(vdd) and an input compares against V(vdd)/2 at every
// instant (plan D-C, P3.2a).
`include "disciplines.vams"
`timescale 1ns/1ps
module por_ctrl(hi, lo_n, por_n, rst_n, tie_hi, clk);
  input hi, lo_n;
  output por_n, rst_n, tie_hi, clk;
  reg por_n, rst_n, tie_hi, clk;
  reg [4:0] cnt;
  initial begin
    por_n = 1'b0; rst_n = 1'b0; tie_hi = 1'b1; clk = 1'b0; cnt = 5'd0;
  end
  always #500 clk = ~clk;
  always @(posedge hi) por_n = 1'b1;
  always @(negedge lo_n) por_n = 1'b0;
  always @(posedge clk) begin
    if (!por_n) begin
      cnt <= 5'd0;
      rst_n <= 1'b0;
    end else if (cnt != 5'd16) begin
      cnt <= cnt + 5'd1;
    end else begin
      rst_n <= 1'b1;
    end
  end
endmodule

connectmodule a2d(a, d);
    input a;
    output d;
    electrical a;
    logic d;

    parameter real vsup = 3.3;
    parameter real tdrise = 1e-9;
    parameter real tdfall = 1e-9;
endmodule

connectmodule d2a(d, a);
    input d;
    output a;
    logic d;
    electrical a;

    parameter real vsup = 3.3;
    parameter real trise = 1e-9;
    parameter real tfall = 1e-9;
endmodule

connectrules por_live;
  connect a2d #(.vsup(vdd));
  connect d2a #(.vsup(vdd));
endconnectrules
