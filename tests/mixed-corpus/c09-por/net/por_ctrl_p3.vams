// C9 variant p3 (RSpice-authored; corpus design C9, amendment A4): the
// controller of net/por_ctrl.v unchanged, with its boundaries converted by
// authored supply-sensitive connect modules. Each converter has a third port,
// the supply it converts against: a 1 drives V(vsup) behind 20 ohm and an
// input compares against V(vsup)/2. The port's inh_conn_def_value names the
// net it binds to, vdd, as Cadence's connect modules name their supplies; vdd
// is a PWL source, so nothing could infer it.
`include "disciplines.vams"
`timescale 1ns/1ps
module por_ctrl(hi, lo_n, por_n, rst_n, tie_hi, clk);
  input hi, lo_n;
  output por_n, rst_n, tie_hi, clk;
  reg por_n, rst_n, tie_hi, clk;
  reg [4:0] cnt;
  initial begin
    por_n = 1'b0; rst_n = 1'b0; tie_hi = 1'b1; clk = 1'b0; cnt = 5'd0;
  end
  always #500 clk = ~clk;
  always @(posedge hi) por_n = 1'b1;
  always @(negedge lo_n) por_n = 1'b0;
  always @(posedge clk) begin
    if (!por_n) begin
      cnt <= 5'd0;
      rst_n <= 1'b0;
    end else if (cnt != 5'd16) begin
      cnt <= cnt + 5'd1;
    end else begin
      rst_n <= 1'b1;
    end
  end
endmodule

connectmodule d2a_sup(d, a, vsup);
  input d; logic d;
  output a; electrical a;
  inout vsup; electrical (* integer inh_conn_def_value = "vdd"; *) vsup;
  analog I(a) <+ (V(a) - (d ? V(vsup) : 0.0)) / 20.0;
endmodule

connectmodule a2d_sup(a, d, vsup);
  input a; electrical a;
  output d; logic d; reg d;
  inout vsup; electrical (* integer inh_conn_def_value = "vdd"; *) vsup;
  initial d = 1'b0;
  always @(above(V(a) - 0.5 * V(vsup)) or above(0.5 * V(vsup) - V(a)))
    d = V(a) >= 0.5 * V(vsup);
endmodule

connectrules por_supply;
  connect d2a_sup;
  connect a2d_sup;
endconnectrules
