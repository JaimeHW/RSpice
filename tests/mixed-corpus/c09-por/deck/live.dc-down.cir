* C9 power-on reset, variant live, dc-down (downward supply sweep; state carried point to point)
* No .param vcc: the connect rules name the vdd net as the supply, bound live.
.hdl "../net/por_ctrl_live.vams" module=por_ctrl
.options connectrules=por_live
.include ../net/por.cir
.dc vdd 3.6 0 -0.01
.end
