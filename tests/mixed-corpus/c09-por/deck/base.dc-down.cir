* C9 power-on reset, variant base, dc-down (downward supply sweep; state carried point to point)
.hdl "../net/por_ctrl.v"
.include ../net/por.cir
.param vcc=3.3
.dc vdd 3.6 0 -0.01
.end
