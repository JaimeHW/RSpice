* Transient noise through a mixed module, its analog-only twin, and a resistor
.hdl "../net/noisy_mixed.vams"
.hdl "../net/noisy_va.va"
x1 p 0 q noisy_mixed
rq q 0 10k
x2 pv 0 noisy_va
rn pn 0 1k
.tran 1n 2u NOISEFMAX=500meg NOISESEED=7
.end
