* Monte Carlo of a transient on a mixed design
.hdl "../net/cnt.vams"
vp p 0 1
x1 p 0 q cnt
rp p 0 {r}
rq q 0 10k
.param r={agauss(1k,100,1)}
.mc 4 seed 9
* The cell reads q on its converter's endpoint, which a run records only when
* named: the deck net q carries the same bit.
.esave x1.q__event_0
.tran 1n 100n
.end
