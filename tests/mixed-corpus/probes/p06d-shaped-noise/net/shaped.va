// P0.6d: a module that shapes its own noise through a single-pole low-pass,
// H(s) = 1/(1 + s/1e6). A pole entry is the root of 1 - s/p (LRM 2.4
// §4.5.13), so the stable pole is the negative one.
`include "disciplines.vams"
module shaped(p, n);
  inout p, n; electrical p, n;
  analog I(p, n) <+ V(p, n)/1000.0 + laplace_np(white_noise(1e-18, "b"), '{1}, '{-1e6, 0});
endmodule
