* C8 tr held-digital O5 circuit (corpus O5 rules): the testbench's real-to-
* voltage output held at its t = 0 value (0 V) as a source; the encoder only
* reads the comparators (V() in its process) and is removed. The runner
* appends the deck's card.
.include ../net/sk_tr.cir
vstim stim 0 0
vac fin stim dc 0 ac 1
.end
