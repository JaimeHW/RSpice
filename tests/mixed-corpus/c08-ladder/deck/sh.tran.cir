* C8 abstraction ladder, variant sh (a timer sample-and-hold rung), tran
* A 0.1 V/us ramp, sampled every 1 us from 0.5 us and slewed at 1 V/us.
.hdl "../net/sh_slew.va"
vin in 0 pwl(0 0 10u 1)
xsh in out sh_slew
.tran 10n 10u
.end
