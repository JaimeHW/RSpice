* C11 switched-capacitor filter, variant pulse, pnoise
* Driven PSS as in deck/pulse.pss.cir, then periodic noise at v(out) sampled
* at 990 ns of the 1 us period (356.4 degrees), in the hold: S2 opens at
* 980.556 ns and closes again at 1.52 us. The contract's samples are the held
* output. Before S2 opens, the noise of its 1 kOhm across C1 and C2 in series
* is still live (tau = 0.9 ns), so a sample at 980 ns would add the part of it
* that decorrelates in the last 0.556 ns.
.include ../net/sc_pulse.cir
vin in 0 dc 0.5 sin(0.5 0.2 1meg 0 0 -83) ac 1
.pss fund=1meg tstab=10u
.pnoise dec 10 100 500k out=v(out) sampling=phase samplephase=356.4
.end
