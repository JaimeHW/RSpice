* C11 switched-capacitor filter, variant pulse, pnoise
* Driven PSS as in deck/pulse.pss.cir, then periodic noise at v(out) sampled
* at 980 ns of the 1 us period (352.8 degrees), 0.556 ns before S2 opens.
.include ../net/sc_pulse.cir
vin in 0 dc 0.5 sin(0.5 0.2 1meg 0 0 -83) ac 1
.pss fund=1meg tstab=10u
.pnoise dec 10 100 500k out=v(out) sampling=phase samplephase=352.8
.end
