* C1 sigma-delta modulator, variant vams, tran
.include ../net/converter.cir
.include ../net/count-latch-dac.cir
.include ../net/mod1int.cir
.hdl "../net/sdq.vams"
xint inp inm adffq adffqb outintp outintn mod1int
xq outintp outintn dclk adffq adffqb dv dvb sdq
vin inp inm dc 0 sin(0 'inampl' 'infreq' 0 0)
* upstream .control: save inp inm adaclout adaccout ; save memory space
.save v(inp) v(inm) v(adaclout) v(adaccout)
.tran 0.1u 2m
.end
