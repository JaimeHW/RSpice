* C1 sigma-delta modulator, variant xs, trnoise
.include ../net/converter.cir
.include ../net/count-latch-dac.cir
.include ../net/mod1-ct.cir
Xmod inp inm dclk dv dvb mod1
vin inp inm dc 0 trnoise(0.1 0.2u 0 0)
* upstream .control: save inp inm adaclout adaccout ; save memory space
.save v(inp) v(inm) v(adaclout) v(adaccout)
.tran 0.2u 5m
.end
