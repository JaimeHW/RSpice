* C1 sigma-delta modulator, variant xs, op in the ngspice dialect
.include ../net/converter.cir
.include ../net/count-latch-dac.cir
.include ../net/mod1-ct.cir
Xmod inp inm dclk dv dvb mod1
vin inp inm dc 0 sin(0 'inampl' 'infreq' 0 0)
.options rspice_dialect=ngspice
.op
.end
