* C1 sigma-delta modulator, variant xs, tran: O1 (ngspice-46) oracle deck
.include ../net/converter.cir
.include ../net/count-latch-dac.cir
.include ../net/mod1-ct.cir
Xmod inp inm dclk dv dvb mod1
vin inp inm dc 0 sin(0 'inampl' 'infreq' 0 0)
.tran 0.1u 2m
.save v(adaclout) v(inp) v(inm)
.end
