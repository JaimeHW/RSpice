* C7 open-drain bus, variant flat (task-free controller script), op
.hdl "../net/i2c_ctrl.v"
.hdl "../net/i2c_dev.v"
.include ../net/bus.cir
xctrl scl sda i2c_ctrl
xdev2a scl sda i2c_dev addr=42
xdev51 scl sda i2c_dev addr=81
.op
.end
