* C7 open-drain bus, variant tasks (controller script written as tasks), op
.hdl "../net/i2c_ctrl_tasks.v"
.hdl "../net/i2c_dev.v"
.include ../net/bus.cir
xctrl scl sda i2c_ctrl
xdev2a scl sda i2c_dev addr=42
xdev51 scl sda i2c_dev addr=81
.op
.end
