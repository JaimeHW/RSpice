* C7 open-drain bus, variant cont (contention), tran
* The controller holds SDA low over [295, 315] us while i2c_dev51 drives it
* push-pull high over [300, 310] us.
.hdl "../net/i2c_ctrl.v"
.hdl "../net/i2c_dev.v"
.include ../net/bus.cir
xctrl scl sda i2c_ctrl mode=1
xdev2a scl sda i2c_dev addr=42
xdev51 scl sda i2c_dev addr=81 contend=1
.tran 100n 320u
.end
