* C3 d_cosim examples, variants adc and adc_nd, tran: O2 (ngspice-46 + d_cosim + Icarus) oracle deck
* Upstream icarus_verilog/adc.cir with verilator/adc.shared inlined, wired as
* the RSpice decks are:
* - the d_cosim ports RSpice converts with built-in converters get explicit
*   bridges at the same levels and timing: Start through an adc_bridge at
*   vcc/2; Sample through a dac_bridge 0/vcc (X at vcc/2), 1 ps edges, behind
*   20 ohm (the built-in D/A steps);
* - Result passes through the same 1 ps XSPICE inverters into d5..d0 in place
*   of the inverted `~d5..~d0` ports, so Sample opens the input switch before
*   the first capacitor bit moves, as in RSpice; d5..d0 reach their analog
*   loads through ngspice's own bridging, as RSpice's;
* - d_cosim's output delay is its 1 ps minimum (default 1 ns);
* - the valid_d observer is net/adc_observe.cir.
* rspice-events: d5 d4 d3 d2 d1 d0 valid_d

.model dut d_cosim simulation="ivlng" sim_args=["adc"] delay=1e-12

.subckt sar_adc input vref start valid d5 d4 d3 d2 d1 d0 clk

xsample input iin sample vref tgate
rin iin test_v 1k

xb5 test_v vref d5 ccap c=1p
xb4 test_v vref d4 ccap c={1p / 2}
xb3 test_v vref d3 ccap c={1p / 4}
xb2 test_v vref d2 ccap c={1p / 8}
xb1 test_v vref d1 ccap c={1p / 16}
xb0 test_v vref d0 ccap c={1p / 32}
clast test_v 0            {1p / 32}

acomp [%vd(test_v vref)] [comp] comparator
.model comparator adc_bridge in_low=0 in_high=0

adut [ Clk Comp d_start] [d_sample Valid r5 r4 r3 r2 r1 r0] dut
ainv5 r5 d5 dinv
ainv4 r4 d4 dinv
ainv3 r3 d3 dinv
ainv2 r2 d2 dinv
ainv1 r1 d1 dinv
ainv0 r0 d0 dinv
.model dinv d_inverter(rise_delay = 1e-12 fall_delay = 1e-12)

astart [start] [d_start] adc_half
.model adc_half adc_bridge(in_low = 1.65 in_high = 1.65)
asample [d_sample] [sample_h] dac_vcc
.model dac_vcc dac_bridge(out_low = 0 out_high = 3.3 out_undef = 1.65
+ t_rise = 1e-12 t_fall = 1e-12)
rsample sample_h sample 20
.ends // SUBCKT sar_adc

.model p1 pmos
+  level=2 vto=-0.5 kp=8.5e-6 gamma=0.4 phi=0.65 lambda=0.05 xj=0.5e-6
.model n1 nmos
+  level=2 vto=0.5 kp=24e-6 gamma=0.15 phi=0.65 lambda=0.015 xj=0.5e-6

.subckt ainv in out vdd
mn out in 0 0 n1
mp out in vdd vdd p1
.ends

.subckt mos_tgate a b ctl vdd
mn a ctl b b n1
xinv ctl ictl vdd ainv
mp b ictl a a p1
.ends

.subckt tgate a b ctl vdd
switch a b ctl 0 tg
.model tg sw vt=1.5 ron=2k
.ends

.subckt ccap in vcc ctl c=10p
xinv ctl tail vcc ainv
cb in tail {c}
.ends

.param vcc=3.3
vcc vcc 0 {vcc}

aclock 0 clk clock
.model clock d_osc cntl_array=[-1 1] freq_array=[1Meg 1Meg]

r5 d5 sum 2
r4 d4 sum 4
r3 d3 sum 8
r2 d2 sum 16
r1 d1 sum 32
r0 d0 sum 64

vamm sum 0 0

Vpulse Start 0 PULSE 0 {vcc} 0.2u 10n 10n 1.3u 10u
Vtest input 0 PULSE 0 3 0 200u 200u 1u 401u

xtest input vcc start valid d5 d4 d3 d2 d1 d0 clk sar_adc

avalid_d valid valid_d dly10n
.model dly10n d_buffer(rise_delay = 10n fall_delay = 10n)

.tran 100n 129.75u
.save v(input) v(xtest.test_v)
.end
