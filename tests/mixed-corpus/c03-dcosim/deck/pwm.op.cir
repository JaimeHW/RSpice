* C3 d_cosim examples, variant pwm, op
.verilog "../net/pwm.v" pwm
.include ../net/pwm.cir
.param vcc=3.3
xdut out pwm cycles=100 samples=100
* A 1 kOhm pull-up to vcc on out reads the D/A that drives it: out = 0 at the
* operating point, so out sits at vcc * 20 / (20 + 1k), the D/A's 20 ohm low
* level against the pull-up, and smooth with it (c1 is open).
vpu pu 0 {vcc}
rpu out pu 1k
.op
.end
