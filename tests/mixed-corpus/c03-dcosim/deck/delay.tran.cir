* C3 d_cosim examples, variant delay, tran
.verilog "../net/delay.v" delay
.include ../net/delay.cir
.param vcc=3.3
.tran 20u 100u
.end
