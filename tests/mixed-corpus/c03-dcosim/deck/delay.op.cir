* C3 d_cosim examples, variant delay, op
.verilog "../net/delay.v" delay
.include ../net/delay.cir
.param vcc=3.3
.op
.end
