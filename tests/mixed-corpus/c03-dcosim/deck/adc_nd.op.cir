* C3 d_cosim examples, variant adc_nd (adc.v without its $display line), op
.verilog "../net/adc_nd.v" adc
.include ../net/adc.shared
.include ../net/adc_observe.cir
.op
.end
