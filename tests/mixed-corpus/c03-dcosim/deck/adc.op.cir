* C3 d_cosim examples, variant adc, op
.verilog "../net/adc.v" adc
.include ../net/adc.shared
.include ../net/adc_observe.cir
.op
.end
