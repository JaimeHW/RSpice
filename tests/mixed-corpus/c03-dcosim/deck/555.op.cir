* C3 d_cosim examples, variant 555, op
.verilog "../net/555.v" vl555
.include ../net/555.shared
.op
.end
