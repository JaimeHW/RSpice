* C3 d_cosim examples, variant delay_v2005 (delay.v in 1364-2005 spelling), tran
.verilog "../net/delay_v2005.v" delay
.include ../net/delay.cir
.param vcc=3.3
.tran 20u 100u
.end
