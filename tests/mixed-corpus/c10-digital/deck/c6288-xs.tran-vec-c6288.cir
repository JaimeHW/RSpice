* C10 c6288, variant c6288-xs, tran-vec-c6288
.include ../net/c6288_xs.cir
.include ../net/c6288_vectors.cir
.include ../net/strobe_vectors.cir
.tran 1n 80n
.end
