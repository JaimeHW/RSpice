* C10 c432, variant c432-xs, tran
.include ../net/c432_xs.cir
.include ../net/c432_pulse.cir
.include ../net/strobe_iscas.cir
.tran 1p 1n
.end
