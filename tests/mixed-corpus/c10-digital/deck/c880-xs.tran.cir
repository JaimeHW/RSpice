* C10 c880, variant c880-xs, tran
.include ../net/c880_xs.cir
.include ../net/c880_pulse.cir
.include ../net/strobe_iscas.cir
.tran 1p 1n
.end
