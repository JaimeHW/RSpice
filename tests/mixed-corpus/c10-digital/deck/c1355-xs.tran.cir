* C10 c1355, variant c1355-xs, tran
.include ../net/c1355_xs.cir
.include ../net/c1355_pulse.cir
.include ../net/strobe_iscas.cir
.tran 1p 1n
.end
