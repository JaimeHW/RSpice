* C10 c1908, variant c1908-xs, tran
.include ../net/c1908_xs.cir
.include ../net/c1908_pulse.cir
.include ../net/strobe_iscas.cir
.tran 1p 1n
.end
