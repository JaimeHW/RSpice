* C10 c1355, variant c1355-xs, tran-vec
.include ../net/c1355_xs.cir
.include ../net/c1355_vectors.cir
.include ../net/strobe_vectors.cir
.tran 1n 640n
.end
