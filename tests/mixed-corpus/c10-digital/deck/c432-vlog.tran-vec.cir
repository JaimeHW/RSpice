* C10 c432, variant c432-vlog, tran-vec
.hdl "../net/c432.v"
xdut g35 g21 g18 g23 g13 g2 g31 g9 g17 g27 g14 g36 g19 g8 g3 g26 g16 g11 g22 g32 g30 g10 g6 g1 g28
+ g25 g4 g15 g12 g29 g33 g7 g24 g34 g20 g5 g426 g427 g428 g429 g430 g431 g432 c432
.param vcc=1.0
.include ../net/c432_vectors.cir
.include ../net/strobe_vectors.cir
* The cells read each port on its converter's endpoint, which a run records
* only when named: the deck nets carry the same bits.
.esave d_stb xdut.g35__event_0 xdut.g21__event_0 xdut.g18__event_0 xdut.g23__event_0
+ xdut.g13__event_0 xdut.g2__event_0 xdut.g31__event_0 xdut.g9__event_0 xdut.g17__event_0
+ xdut.g27__event_0 xdut.g14__event_0 xdut.g36__event_0 xdut.g19__event_0 xdut.g8__event_0
+ xdut.g3__event_0 xdut.g26__event_0 xdut.g16__event_0 xdut.g11__event_0 xdut.g22__event_0
+ xdut.g32__event_0 xdut.g30__event_0 xdut.g10__event_0 xdut.g6__event_0 xdut.g1__event_0
+ xdut.g28__event_0 xdut.g25__event_0 xdut.g4__event_0 xdut.g15__event_0 xdut.g12__event_0
+ xdut.g29__event_0 xdut.g33__event_0 xdut.g7__event_0 xdut.g24__event_0 xdut.g34__event_0
+ xdut.g20__event_0 xdut.g5__event_0 xdut.g426__event_0 xdut.g427__event_0 xdut.g428__event_0
+ xdut.g429__event_0 xdut.g430__event_0 xdut.g431__event_0 xdut.g432__event_0
.tran 1n 640n
.end
