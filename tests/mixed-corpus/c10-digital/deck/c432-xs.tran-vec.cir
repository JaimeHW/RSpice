* C10 c432, variant c432-xs, tran-vec
.include ../net/c432_xs.cir
.include ../net/c432_vectors.cir
.include ../net/strobe_vectors.cir
.tran 1n 640n
.end
