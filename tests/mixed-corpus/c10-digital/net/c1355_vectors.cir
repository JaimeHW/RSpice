* C10 c1355: 64 random input vectors (Python random.Random(1).getrandbits(1) per input,
* vector-major, inputs in deck order), one per 10 ns with 10 ps transitions.
vg21 g21 0 pwl( 0 0 10n 0 10.01n 1 60n 1 60.01n 0 110n 0 110.01n 1 130n 1 130.01n 0 170n 0 170.01n 1
+ 180n 1 180.01n 0 190n 0 190.01n 1 210n 1 210.01n 0 240n 0 240.01n 1 250n 1 250.01n 0 280n 0
+ 280.01n 1 290n 1 290.01n 0 300n 0 300.01n 1 350n 1 350.01n 0 360n 0 360.01n 1 370n 1 370.01n 0
+ 420n 0 420.01n 1 450n 1 450.01n 0 470n 0 470.01n 1 520n 1 520.01n 0 530n 0 530.01n 1 540n 1
+ 540.01n 0 550n 0 550.01n 1 560n 1 560.01n 0 590n 0 590.01n 1 600n 1 600.01n 0)
vg18 g18 0 pwl( 0 1 20n 1 20.01n 0 30n 0 30.01n 1 50n 1 50.01n 0 60n 0 60.01n 1 70n 1 70.01n 0 80n 0
+ 80.01n 1 90n 1 90.01n 0 100n 0 100.01n 1 130n 1 130.01n 0 150n 0 150.01n 1 170n 1 170.01n 0 190n 0
+ 190.01n 1 200n 1 200.01n 0 210n 0 210.01n 1 220n 1 220.01n 0 260n 0 260.01n 1 270n 1 270.01n 0
+ 290n 0 290.01n 1 300n 1 300.01n 0 400n 0 400.01n 1 430n 1 430.01n 0 450n 0 450.01n 1 460n 1
+ 460.01n 0 480n 0 480.01n 1 510n 1 510.01n 0 520n 0 520.01n 1 540n 1 540.01n 0 570n 0 570.01n 1
+ 580n 1 580.01n 0 620n 0 620.01n 1)
vg31 g31 0 pwl( 0 1 10n 1 10.01n 0 30n 0 30.01n 1 40n 1 40.01n 0 50n 0 50.01n 1 60n 1 60.01n 0 80n 0
+ 80.01n 1 110n 1 110.01n 0 130n 0 130.01n 1 150n 1 150.01n 0 160n 0 160.01n 1 180n 1 180.01n 0 190n
+ 0 190.01n 1 200n 1 200.01n 0 210n 0 210.01n 1 220n 1 220.01n 0 240n 0 240.01n 1 260n 1 260.01n 0
+ 270n 0 270.01n 1 290n 1 290.01n 0 300n 0 300.01n 1 320n 1 320.01n 0 340n 0 340.01n 1 350n 1
+ 350.01n 0 400n 0 400.01n 1 410n 1 410.01n 0 420n 0 420.01n 1 440n 1 440.01n 0 460n 0 460.01n 1
+ 470n 1 470.01n 0 500n 0 500.01n 1 520n 1 520.01n 0 530n 0 530.01n 1 590n 1 590.01n 0 600n 0
+ 600.01n 1 610n 1 610.01n 0)
vg17 g17 0 pwl( 0 1 40n 1 40.01n 0 50n 0 50.01n 1 60n 1 60.01n 0 70n 0 70.01n 1 110n 1 110.01n 0
+ 120n 0 120.01n 1 130n 1 130.01n 0 180n 0 180.01n 1 190n 1 190.01n 0 220n 0 220.01n 1 250n 1
+ 250.01n 0 290n 0 290.01n 1 310n 1 310.01n 0 340n 0 340.01n 1 360n 1 360.01n 0 370n 0 370.01n 1
+ 380n 1 380.01n 0 390n 0 390.01n 1 420n 1 420.01n 0 430n 0 430.01n 1 440n 1 440.01n 0 450n 0
+ 450.01n 1 520n 1 520.01n 0 530n 0 530.01n 1 550n 1 550.01n 0 600n 0 600.01n 1 620n 1 620.01n 0
+ 630n 0 630.01n 1)
vg27 g27 0 pwl( 0 1 20n 1 20.01n 0 30n 0 30.01n 1 50n 1 50.01n 0 70n 0 70.01n 1 80n 1 80.01n 0 90n 0
+ 90.01n 1 110n 1 110.01n 0 140n 0 140.01n 1 160n 1 160.01n 0 170n 0 170.01n 1 180n 1 180.01n 0 190n
+ 0 190.01n 1 220n 1 220.01n 0 240n 0 240.01n 1 280n 1 280.01n 0 290n 0 290.01n 1 300n 1 300.01n 0
+ 320n 0 320.01n 1 330n 1 330.01n 0 360n 0 360.01n 1 380n 1 380.01n 0 430n 0 430.01n 1 440n 1
+ 440.01n 0 460n 0 460.01n 1 470n 1 470.01n 0 490n 0 490.01n 1 510n 1 510.01n 0 540n 0 540.01n 1
+ 550n 1 550.01n 0 570n 0 570.01n 1 610n 1 610.01n 0 620n 0 620.01n 1 630n 1 630.01n 0)
vg11 g11 0 pwl( 0 0 20n 0 20.01n 1 30n 1 30.01n 0 60n 0 60.01n 1 100n 1 100.01n 0 120n 0 120.01n 1
+ 150n 1 150.01n 0 170n 0 170.01n 1 180n 1 180.01n 0 190n 0 190.01n 1 200n 1 200.01n 0 210n 0
+ 210.01n 1 220n 1 220.01n 0 240n 0 240.01n 1 250n 1 250.01n 0 260n 0 260.01n 1 290n 1 290.01n 0
+ 310n 0 310.01n 1 320n 1 320.01n 0 390n 0 390.01n 1 420n 1 420.01n 0 490n 0 490.01n 1 500n 1
+ 500.01n 0 530n 0 530.01n 1 540n 1 540.01n 0 580n 0 580.01n 1 600n 1 600.01n 0 610n 0 610.01n 1)
vg22 g22 0 pwl( 0 0 10n 0 10.01n 1 30n 1 30.01n 0 40n 0 40.01n 1 100n 1 100.01n 0 130n 0 130.01n 1
+ 150n 1 150.01n 0 160n 0 160.01n 1 180n 1 180.01n 0 190n 0 190.01n 1 220n 1 220.01n 0 240n 0
+ 240.01n 1 270n 1 270.01n 0 290n 0 290.01n 1 340n 1 340.01n 0 370n 0 370.01n 1 380n 1 380.01n 0
+ 390n 0 390.01n 1 400n 1 400.01n 0 410n 0 410.01n 1 430n 1 430.01n 0 440n 0 440.01n 1 450n 1
+ 450.01n 0 460n 0 460.01n 1 480n 1 480.01n 0 490n 0 490.01n 1 500n 1 500.01n 0 510n 0 510.01n 1
+ 520n 1 520.01n 0 540n 0 540.01n 1 560n 1 560.01n 0 590n 0 590.01n 1 610n 1 610.01n 0 630n 0
+ 630.01n 1)
vg32 g32 0 pwl( 0 0 20n 0 20.01n 1 30n 1 30.01n 0 40n 0 40.01n 1 50n 1 50.01n 0 90n 0 90.01n 1 100n
+ 1 100.01n 0 160n 0 160.01n 1 180n 1 180.01n 0 190n 0 190.01n 1 210n 1 210.01n 0 220n 0 220.01n 1
+ 280n 1 280.01n 0 310n 0 310.01n 1 320n 1 320.01n 0 330n 0 330.01n 1 360n 1 360.01n 0 370n 0
+ 370.01n 1 430n 1 430.01n 0 440n 0 440.01n 1 460n 1 460.01n 0 470n 0 470.01n 1 490n 1 490.01n 0
+ 500n 0 500.01n 1 510n 1 510.01n 0 520n 0 520.01n 1 600n 1 600.01n 0 630n 0 630.01n 1)
vg30 g30 0 pwl( 0 0 10n 0 10.01n 1 50n 1 50.01n 0 70n 0 70.01n 1 80n 1 80.01n 0 90n 0 90.01n 1 100n
+ 1 100.01n 0 120n 0 120.01n 1 130n 1 130.01n 0 170n 0 170.01n 1 180n 1 180.01n 0 210n 0 210.01n 1
+ 240n 1 240.01n 0 250n 0 250.01n 1 290n 1 290.01n 0 310n 0 310.01n 1 330n 1 330.01n 0 340n 0
+ 340.01n 1 350n 1 350.01n 0 370n 0 370.01n 1 390n 1 390.01n 0 400n 0 400.01n 1 410n 1 410.01n 0
+ 450n 0 450.01n 1 470n 1 470.01n 0 480n 0 480.01n 1 500n 1 500.01n 0 530n 0 530.01n 1 550n 1
+ 550.01n 0 580n 0 580.01n 1 600n 1 600.01n 0)
vg4 g4 0 pwl( 0 1 10n 1 10.01n 0 20n 0 20.01n 1 40n 1 40.01n 0 70n 0 70.01n 1 100n 1 100.01n 0 110n
+ 0 110.01n 1 120n 1 120.01n 0 130n 0 130.01n 1 140n 1 140.01n 0 170n 0 170.01n 1 190n 1 190.01n 0
+ 210n 0 210.01n 1 220n 1 220.01n 0 250n 0 250.01n 1 280n 1 280.01n 0 290n 0 290.01n 1 320n 1
+ 320.01n 0 330n 0 330.01n 1 410n 1 410.01n 0 430n 0 430.01n 1 450n 1 450.01n 0 470n 0 470.01n 1
+ 490n 1 490.01n 0 510n 0 510.01n 1 520n 1 520.01n 0 540n 0 540.01n 1 550n 1 550.01n 0 560n 0
+ 560.01n 1 590n 1 590.01n 0 610n 0 610.01n 1)
vg12 g12 0 pwl( 0 0 10n 0 10.01n 1 30n 1 30.01n 0 100n 0 100.01n 1 140n 1 140.01n 0 150n 0 150.01n 1
+ 190n 1 190.01n 0 200n 0 200.01n 1 210n 1 210.01n 0 220n 0 220.01n 1 270n 1 270.01n 0 290n 0
+ 290.01n 1 300n 1 300.01n 0 310n 0 310.01n 1 320n 1 320.01n 0 340n 0 340.01n 1 350n 1 350.01n 0
+ 370n 0 370.01n 1 390n 1 390.01n 0 440n 0 440.01n 1 450n 1 450.01n 0 480n 0 480.01n 1 490n 1
+ 490.01n 0 510n 0 510.01n 1 530n 1 530.01n 0 540n 0 540.01n 1 550n 1 550.01n 0 560n 0 560.01n 1
+ 580n 1 580.01n 0)
vg29 g29 0 pwl( 0 0 20n 0 20.01n 1 80n 1 80.01n 0 110n 0 110.01n 1 130n 1 130.01n 0 140n 0 140.01n 1
+ 190n 1 190.01n 0 200n 0 200.01n 1 220n 1 220.01n 0 230n 0 230.01n 1 240n 1 240.01n 0 250n 0
+ 250.01n 1 270n 1 270.01n 0 290n 0 290.01n 1 320n 1 320.01n 0 350n 0 350.01n 1 360n 1 360.01n 0
+ 370n 0 370.01n 1 380n 1 380.01n 0 390n 0 390.01n 1 460n 1 460.01n 0 510n 0 510.01n 1 570n 1
+ 570.01n 0 580n 0 580.01n 1 590n 1 590.01n 0 600n 0 600.01n 1 620n 1 620.01n 0)
vg24 g24 0 pwl( 0 1 20n 1 20.01n 0 50n 0 50.01n 1 90n 1 90.01n 0 100n 0 100.01n 1 180n 1 180.01n 0
+ 190n 0 190.01n 1 210n 1 210.01n 0 240n 0 240.01n 1 270n 1 270.01n 0 300n 0 300.01n 1 310n 1
+ 310.01n 0 320n 0 320.01n 1 340n 1 340.01n 0 360n 0 360.01n 1 400n 1 400.01n 0 450n 0 450.01n 1
+ 490n 1 490.01n 0 510n 0 510.01n 1 530n 1 530.01n 0 540n 0 540.01n 1 560n 1 560.01n 0 600n 0
+ 600.01n 1)
vg39 g39 0 pwl( 0 0 20n 0 20.01n 1 60n 1 60.01n 0 110n 0 110.01n 1 120n 1 120.01n 0 130n 0 130.01n 1
+ 160n 1 160.01n 0 170n 0 170.01n 1 190n 1 190.01n 0 210n 0 210.01n 1 220n 1 220.01n 0 230n 0
+ 230.01n 1 260n 1 260.01n 0 270n 0 270.01n 1 300n 1 300.01n 0 370n 0 370.01n 1 380n 1 380.01n 0
+ 390n 0 390.01n 1 400n 1 400.01n 0 410n 0 410.01n 1 450n 1 450.01n 0 460n 0 460.01n 1 510n 1
+ 510.01n 0 520n 0 520.01n 1 620n 1 620.01n 0)
vg38 g38 0 pwl( 0 1 60n 1 60.01n 0 80n 0 80.01n 1 90n 1 90.01n 0 100n 0 100.01n 1 120n 1 120.01n 0
+ 130n 0 130.01n 1 160n 1 160.01n 0 170n 0 170.01n 1 210n 1 210.01n 0 220n 0 220.01n 1 240n 1
+ 240.01n 0 280n 0 280.01n 1 300n 1 300.01n 0 310n 0 310.01n 1 360n 1 360.01n 0 370n 0 370.01n 1
+ 380n 1 380.01n 0 410n 0 410.01n 1 440n 1 440.01n 0 450n 0 450.01n 1 470n 1 470.01n 0 480n 0
+ 480.01n 1 490n 1 490.01n 0 550n 0 550.01n 1 560n 1 560.01n 0 570n 0 570.01n 1 590n 1 590.01n 0
+ 600n 0 600.01n 1 610n 1 610.01n 0 620n 0 620.01n 1 630n 1 630.01n 0)
vg20 g20 0 pwl( 0 0 20n 0 20.01n 1 30n 1 30.01n 0 40n 0 40.01n 1 60n 1 60.01n 0 100n 0 100.01n 1
+ 150n 1 150.01n 0 160n 0 160.01n 1 180n 1 180.01n 0 220n 0 220.01n 1 240n 1 240.01n 0 250n 0
+ 250.01n 1 270n 1 270.01n 0 280n 0 280.01n 1 290n 1 290.01n 0 310n 0 310.01n 1 320n 1 320.01n 0
+ 330n 0 330.01n 1 350n 1 350.01n 0 360n 0 360.01n 1 380n 1 380.01n 0 410n 0 410.01n 1 440n 1
+ 440.01n 0 450n 0 450.01n 1 470n 1 470.01n 0 480n 0 480.01n 1 490n 1 490.01n 0 500n 0 500.01n 1
+ 520n 1 520.01n 0 530n 0 530.01n 1 570n 1 570.01n 0 590n 0 590.01n 1 630n 1 630.01n 0)
vg5 g5 0 pwl( 0 0 10n 0 10.01n 1 30n 1 30.01n 0 40n 0 40.01n 1 50n 1 50.01n 0 90n 0 90.01n 1 100n 1
+ 100.01n 0 130n 0 130.01n 1 150n 1 150.01n 0 160n 0 160.01n 1 170n 1 170.01n 0 190n 0 190.01n 1
+ 220n 1 220.01n 0 230n 0 230.01n 1 270n 1 270.01n 0 280n 0 280.01n 1 310n 1 310.01n 0 340n 0
+ 340.01n 1 360n 1 360.01n 0 380n 0 380.01n 1 410n 1 410.01n 0 430n 0 430.01n 1 440n 1 440.01n 0
+ 510n 0 510.01n 1 530n 1 530.01n 0 550n 0 550.01n 1 560n 1 560.01n 0 580n 0 580.01n 1 590n 1
+ 590.01n 0 600n 0 600.01n 1 630n 1 630.01n 0)
vg35 g35 0 pwl( 0 0 40n 0 40.01n 1 50n 1 50.01n 0 90n 0 90.01n 1 110n 1 110.01n 0 140n 0 140.01n 1
+ 150n 1 150.01n 0 160n 0 160.01n 1 170n 1 170.01n 0 180n 0 180.01n 1 190n 1 190.01n 0 210n 0
+ 210.01n 1 250n 1 250.01n 0 280n 0 280.01n 1 300n 1 300.01n 0 320n 0 320.01n 1 330n 1 330.01n 0
+ 340n 0 340.01n 1 360n 1 360.01n 0 370n 0 370.01n 1 430n 1 430.01n 0 440n 0 440.01n 1 470n 1
+ 470.01n 0 510n 0 510.01n 1 520n 1 520.01n 0 560n 0 560.01n 1 600n 1 600.01n 0 610n 0 610.01n 1
+ 630n 1 630.01n 0)
vg23 g23 0 pwl( 0 0 10n 0 10.01n 1 20n 1 20.01n 0 30n 0 30.01n 1 40n 1 40.01n 0 50n 0 50.01n 1 60n 1
+ 60.01n 0 80n 0 80.01n 1 150n 1 150.01n 0 200n 0 200.01n 1 210n 1 210.01n 0 250n 0 250.01n 1 280n 1
+ 280.01n 0 290n 0 290.01n 1 300n 1 300.01n 0 310n 0 310.01n 1 320n 1 320.01n 0 330n 0 330.01n 1
+ 380n 1 380.01n 0 390n 0 390.01n 1 410n 1 410.01n 0 460n 0 460.01n 1 490n 1 490.01n 0 530n 0
+ 530.01n 1 560n 1 560.01n 0 570n 0 570.01n 1 580n 1 580.01n 0 600n 0 600.01n 1 620n 1 620.01n 0)
vg13 g13 0 pwl( 0 1 10n 1 10.01n 0 70n 0 70.01n 1 80n 1 80.01n 0 100n 0 100.01n 1 120n 1 120.01n 0
+ 150n 0 150.01n 1 160n 1 160.01n 0 180n 0 180.01n 1 270n 1 270.01n 0 290n 0 290.01n 1 300n 1
+ 300.01n 0 310n 0 310.01n 1 330n 1 330.01n 0 340n 0 340.01n 1 350n 1 350.01n 0 370n 0 370.01n 1
+ 440n 1 440.01n 0 460n 0 460.01n 1 490n 1 490.01n 0 500n 0 500.01n 1 510n 1 510.01n 0 530n 0
+ 530.01n 1 540n 1 540.01n 0 550n 0 550.01n 1 580n 1 580.01n 0 590n 0 590.01n 1 630n 1 630.01n 0)
vg2 g2 0 pwl( 0 1 10n 1 10.01n 0 20n 0 20.01n 1 30n 1 30.01n 0 40n 0 40.01n 1 80n 1 80.01n 0 90n 0
+ 90.01n 1 180n 1 180.01n 0 190n 0 190.01n 1 220n 1 220.01n 0 240n 0 240.01n 1 270n 1 270.01n 0 280n
+ 0 280.01n 1 290n 1 290.01n 0 300n 0 300.01n 1 310n 1 310.01n 0 320n 0 320.01n 1 340n 1 340.01n 0
+ 350n 0 350.01n 1 380n 1 380.01n 0 470n 0 470.01n 1 480n 1 480.01n 0 490n 0 490.01n 1 510n 1
+ 510.01n 0 520n 0 520.01n 1 530n 1 530.01n 0 560n 0 560.01n 1 590n 1 590.01n 0 610n 0 610.01n 1)
vg37 g37 0 pwl( 0 0 20n 0 20.01n 1 30n 1 30.01n 0 40n 0 40.01n 1 50n 1 50.01n 0 60n 0 60.01n 1 70n 1
+ 70.01n 0 80n 0 80.01n 1 90n 1 90.01n 0 100n 0 100.01n 1 110n 1 110.01n 0 150n 0 150.01n 1 160n 1
+ 160.01n 0 180n 0 180.01n 1 210n 1 210.01n 0 270n 0 270.01n 1 290n 1 290.01n 0 340n 0 340.01n 1
+ 350n 1 350.01n 0 380n 0 380.01n 1 390n 1 390.01n 0 400n 0 400.01n 1 440n 1 440.01n 0 460n 0
+ 460.01n 1 470n 1 470.01n 0 500n 0 500.01n 1 510n 1 510.01n 0 520n 0 520.01n 1 530n 1 530.01n 0
+ 550n 0 550.01n 1 580n 1 580.01n 0 600n 0 600.01n 1 630n 1 630.01n 0)
vg41 g41 0 pwl( 0 0 10n 0 10.01n 1 30n 1 30.01n 0 40n 0 40.01n 1 60n 1 60.01n 0 80n 0 80.01n 1 90n 1
+ 90.01n 0 150n 0 150.01n 1 170n 1 170.01n 0 190n 0 190.01n 1 220n 1 220.01n 0 250n 0 250.01n 1 270n
+ 1 270.01n 0 280n 0 280.01n 1 310n 1 310.01n 0 320n 0 320.01n 1 330n 1 330.01n 0 360n 0 360.01n 1
+ 380n 1 380.01n 0 410n 0 410.01n 1 430n 1 430.01n 0 460n 0 460.01n 1 470n 1 470.01n 0 480n 0
+ 480.01n 1 490n 1 490.01n 0 500n 0 500.01n 1 510n 1 510.01n 0 540n 0 540.01n 1 560n 1 560.01n 0
+ 570n 0 570.01n 1 580n 1 580.01n 0)
vg9 g9 0 pwl( 0 1 10n 1 10.01n 0 30n 0 30.01n 1 50n 1 50.01n 0 60n 0 60.01n 1 80n 1 80.01n 0 100n 0
+ 100.01n 1 110n 1 110.01n 0 120n 0 120.01n 1 130n 1 130.01n 0 150n 0 150.01n 1 160n 1 160.01n 0
+ 170n 0 170.01n 1 180n 1 180.01n 0 190n 0 190.01n 1 200n 1 200.01n 0 210n 0 210.01n 1 220n 1
+ 220.01n 0 230n 0 230.01n 1 240n 1 240.01n 0 250n 0 250.01n 1 260n 1 260.01n 0 270n 0 270.01n 1
+ 280n 1 280.01n 0 300n 0 300.01n 1 310n 1 310.01n 0 340n 0 340.01n 1 370n 1 370.01n 0 400n 0
+ 400.01n 1 440n 1 440.01n 0 450n 0 450.01n 1 490n 1 490.01n 0 520n 0 520.01n 1 530n 1 530.01n 0
+ 540n 0 540.01n 1 570n 1 570.01n 0 580n 0 580.01n 1 590n 1 590.01n 0 600n 0 600.01n 1 610n 1
+ 610.01n 0 620n 0 620.01n 1 630n 1 630.01n 0)
vg40 g40 0 pwl( 0 1 60n 1 60.01n 0 70n 0 70.01n 1 110n 1 110.01n 0 120n 0 120.01n 1 130n 1 130.01n 0
+ 140n 0 140.01n 1 150n 1 150.01n 0 160n 0 160.01n 1 180n 1 180.01n 0 190n 0 190.01n 1 200n 1
+ 200.01n 0 210n 0 210.01n 1 230n 1 230.01n 0 250n 0 250.01n 1 260n 1 260.01n 0 270n 0 270.01n 1
+ 280n 1 280.01n 0 290n 0 290.01n 1 300n 1 300.01n 0 380n 0 380.01n 1 440n 1 440.01n 0 480n 0
+ 480.01n 1 490n 1 490.01n 0 500n 0 500.01n 1 510n 1 510.01n 0 520n 0 520.01n 1 540n 1 540.01n 0
+ 570n 0 570.01n 1 590n 1 590.01n 0 600n 0 600.01n 1 610n 1 610.01n 0 620n 0 620.01n 1)
vg14 g14 0 pwl( 0 1 10n 1 10.01n 0 20n 0 20.01n 1 80n 1 80.01n 0 90n 0 90.01n 1 110n 1 110.01n 0
+ 130n 0 130.01n 1 140n 1 140.01n 0 160n 0 160.01n 1 190n 1 190.01n 0 210n 0 210.01n 1 270n 1
+ 270.01n 0 290n 0 290.01n 1 300n 1 300.01n 0 340n 0 340.01n 1 350n 1 350.01n 0 390n 0 390.01n 1
+ 400n 1 400.01n 0 430n 0 430.01n 1 450n 1 450.01n 0 460n 0 460.01n 1 470n 1 470.01n 0 490n 0
+ 490.01n 1 500n 1 500.01n 0 540n 0 540.01n 1 550n 1 550.01n 0 560n 0 560.01n 1 570n 1 570.01n 0
+ 580n 0 580.01n 1 590n 1 590.01n 0 610n 0 610.01n 1 630n 1 630.01n 0)
vg36 g36 0 pwl( 0 0 10n 0 10.01n 1 50n 1 50.01n 0 60n 0 60.01n 1 70n 1 70.01n 0 180n 0 180.01n 1
+ 200n 1 200.01n 0 210n 0 210.01n 1 220n 1 220.01n 0 250n 0 250.01n 1 270n 1 270.01n 0 280n 0
+ 280.01n 1 290n 1 290.01n 0 320n 0 320.01n 1 330n 1 330.01n 0 400n 0 400.01n 1 410n 1 410.01n 0
+ 420n 0 420.01n 1 430n 1 430.01n 0 450n 0 450.01n 1 460n 1 460.01n 0 470n 0 470.01n 1 480n 1
+ 480.01n 0 490n 0 490.01n 1 520n 1 520.01n 0 540n 0 540.01n 1 570n 1 570.01n 0 590n 0 590.01n 1
+ 610n 1 610.01n 0 630n 0 630.01n 1)
vg19 g19 0 pwl( 0 1 10n 1 10.01n 0 30n 0 30.01n 1 60n 1 60.01n 0 70n 0 70.01n 1 90n 1 90.01n 0 110n
+ 0 110.01n 1 120n 1 120.01n 0 190n 0 190.01n 1 200n 1 200.01n 0 210n 0 210.01n 1 240n 1 240.01n 0
+ 280n 0 280.01n 1 300n 1 300.01n 0 320n 0 320.01n 1 380n 1 380.01n 0 390n 0 390.01n 1 410n 1
+ 410.01n 0 420n 0 420.01n 1 430n 1 430.01n 0 440n 0 440.01n 1 450n 1 450.01n 0 460n 0 460.01n 1
+ 490n 1 490.01n 0 510n 0 510.01n 1 570n 1 570.01n 0 620n 0 620.01n 1 630n 1 630.01n 0)
vg8 g8 0 pwl( 0 0 10n 0 10.01n 1 50n 1 50.01n 0 70n 0 70.01n 1 80n 1 80.01n 0 90n 0 90.01n 1 120n 1
+ 120.01n 0 150n 0 150.01n 1 160n 1 160.01n 0 170n 0 170.01n 1 180n 1 180.01n 0 210n 0 210.01n 1
+ 220n 1 220.01n 0 230n 0 230.01n 1 240n 1 240.01n 0 250n 0 250.01n 1 270n 1 270.01n 0 280n 0
+ 280.01n 1 290n 1 290.01n 0 310n 0 310.01n 1 330n 1 330.01n 0 340n 0 340.01n 1 350n 1 350.01n 0
+ 380n 0 380.01n 1 400n 1 400.01n 0 420n 0 420.01n 1 430n 1 430.01n 0 470n 0 470.01n 1 480n 1
+ 480.01n 0 490n 0 490.01n 1 500n 1 500.01n 0 520n 0 520.01n 1 530n 1 530.01n 0 550n 0 550.01n 1
+ 570n 1 570.01n 0 580n 0 580.01n 1 620n 1 620.01n 0)
vg3 g3 0 pwl( 0 0 20n 0 20.01n 1 30n 1 30.01n 0 50n 0 50.01n 1 70n 1 70.01n 0 110n 0 110.01n 1 130n
+ 1 130.01n 0 160n 0 160.01n 1 170n 1 170.01n 0 180n 0 180.01n 1 190n 1 190.01n 0 200n 0 200.01n 1
+ 230n 1 230.01n 0 240n 0 240.01n 1 250n 1 250.01n 0 260n 0 260.01n 1 290n 1 290.01n 0 320n 0
+ 320.01n 1 350n 1 350.01n 0 360n 0 360.01n 1 370n 1 370.01n 0 400n 0 400.01n 1 430n 1 430.01n 0
+ 470n 0 470.01n 1 480n 1 480.01n 0 490n 0 490.01n 1 530n 1 530.01n 0 550n 0 550.01n 1 570n 1
+ 570.01n 0 610n 0 610.01n 1 630n 1 630.01n 0)
vg26 g26 0 pwl( 0 1 10n 1 10.01n 0 30n 0 30.01n 1 60n 1 60.01n 0 70n 0 70.01n 1 80n 1 80.01n 0 120n
+ 0 120.01n 1 140n 1 140.01n 0 160n 0 160.01n 1 180n 1 180.01n 0 190n 0 190.01n 1 210n 1 210.01n 0
+ 260n 0 260.01n 1 270n 1 270.01n 0 280n 0 280.01n 1 290n 1 290.01n 0 310n 0 310.01n 1 320n 1
+ 320.01n 0 350n 0 350.01n 1 370n 1 370.01n 0 380n 0 380.01n 1 390n 1 390.01n 0 400n 0 400.01n 1
+ 430n 1 430.01n 0 440n 0 440.01n 1 450n 1 450.01n 0 470n 0 470.01n 1 500n 1 500.01n 0 510n 0
+ 510.01n 1 550n 1 550.01n 0 560n 0 560.01n 1 580n 1 580.01n 0 590n 0 590.01n 1 610n 1 610.01n 0)
vg16 g16 0 pwl( 0 1 20n 1 20.01n 0 40n 0 40.01n 1 60n 1 60.01n 0 70n 0 70.01n 1 90n 1 90.01n 0 110n
+ 0 110.01n 1 150n 1 150.01n 0 160n 0 160.01n 1 180n 1 180.01n 0 200n 0 200.01n 1 210n 1 210.01n 0
+ 220n 0 220.01n 1 230n 1 230.01n 0 250n 0 250.01n 1 260n 1 260.01n 0 280n 0 280.01n 1 310n 1
+ 310.01n 0 320n 0 320.01n 1 350n 1 350.01n 0 380n 0 380.01n 1 390n 1 390.01n 0 410n 0 410.01n 1
+ 440n 1 440.01n 0 460n 0 460.01n 1 470n 1 470.01n 0 490n 0 490.01n 1 510n 1 510.01n 0 520n 0
+ 520.01n 1 530n 1 530.01n 0 540n 0 540.01n 1 550n 1 550.01n 0 570n 0 570.01n 1 580n 1 580.01n 0
+ 620n 0 620.01n 1)
vg10 g10 0 pwl( 0 0 10n 0 10.01n 1 20n 1 20.01n 0 40n 0 40.01n 1 60n 1 60.01n 0 70n 0 70.01n 1 100n
+ 1 100.01n 0 130n 0 130.01n 1 140n 1 140.01n 0 160n 0 160.01n 1 170n 1 170.01n 0 180n 0 180.01n 1
+ 220n 1 220.01n 0 230n 0 230.01n 1 270n 1 270.01n 0 290n 0 290.01n 1 300n 1 300.01n 0 320n 0
+ 320.01n 1 360n 1 360.01n 0 380n 0 380.01n 1 390n 1 390.01n 0 420n 0 420.01n 1 480n 1 480.01n 0
+ 500n 0 500.01n 1 510n 1 510.01n 0 520n 0 520.01n 1 550n 1 550.01n 0 560n 0 560.01n 1 570n 1
+ 570.01n 0 630n 0 630.01n 1)
vg6 g6 0 pwl( 0 1 40n 1 40.01n 0 50n 0 50.01n 1 60n 1 60.01n 0 70n 0 70.01n 1 100n 1 100.01n 0 150n
+ 0 150.01n 1 180n 1 180.01n 0 190n 0 190.01n 1 220n 1 220.01n 0 240n 0 240.01n 1 260n 1 260.01n 0
+ 270n 0 270.01n 1 280n 1 280.01n 0 300n 0 300.01n 1 320n 1 320.01n 0 330n 0 330.01n 1 340n 1
+ 340.01n 0 360n 0 360.01n 1 380n 1 380.01n 0 390n 0 390.01n 1 420n 1 420.01n 0 430n 0 430.01n 1
+ 470n 1 470.01n 0 490n 0 490.01n 1 510n 1 510.01n 0 530n 0 530.01n 1 560n 1 560.01n 0 580n 0
+ 580.01n 1)
vg1 g1 0 pwl( 0 1 30n 1 30.01n 0 50n 0 50.01n 1 60n 1 60.01n 0 70n 0 70.01n 1 80n 1 80.01n 0 100n 0
+ 100.01n 1 110n 1 110.01n 0 130n 0 130.01n 1 160n 1 160.01n 0 190n 0 190.01n 1 200n 1 200.01n 0
+ 220n 0 220.01n 1 250n 1 250.01n 0 260n 0 260.01n 1 300n 1 300.01n 0 340n 0 340.01n 1 360n 1
+ 360.01n 0 380n 0 380.01n 1 390n 1 390.01n 0 410n 0 410.01n 1 440n 1 440.01n 0 460n 0 460.01n 1
+ 480n 1 480.01n 0 500n 0 500.01n 1 510n 1 510.01n 0 520n 0 520.01n 1 530n 1 530.01n 0 560n 0
+ 560.01n 1 590n 1 590.01n 0 630n 0 630.01n 1)
vg28 g28 0 pwl( 0 0 10n 0 10.01n 1 20n 1 20.01n 0 30n 0 30.01n 1 50n 1 50.01n 0 70n 0 70.01n 1 150n
+ 1 150.01n 0 170n 0 170.01n 1 180n 1 180.01n 0 190n 0 190.01n 1 200n 1 200.01n 0 210n 0 210.01n 1
+ 250n 1 250.01n 0 270n 0 270.01n 1 300n 1 300.01n 0 330n 0 330.01n 1 340n 1 340.01n 0 350n 0
+ 350.01n 1 370n 1 370.01n 0 380n 0 380.01n 1 410n 1 410.01n 0 430n 0 430.01n 1 450n 1 450.01n 0
+ 470n 0 470.01n 1 480n 1 480.01n 0 510n 0 510.01n 1 530n 1 530.01n 0 550n 0 550.01n 1 580n 1
+ 580.01n 0 590n 0 590.01n 1 600n 1 600.01n 0 610n 0 610.01n 1 620n 1 620.01n 0)
vg25 g25 0 pwl( 0 1 10n 1 10.01n 0 80n 0 80.01n 1 90n 1 90.01n 0 110n 0 110.01n 1 130n 1 130.01n 0
+ 150n 0 150.01n 1 170n 1 170.01n 0 200n 0 200.01n 1 230n 1 230.01n 0 250n 0 250.01n 1 270n 1
+ 270.01n 0 290n 0 290.01n 1 300n 1 300.01n 0 310n 0 310.01n 1 320n 1 320.01n 0 340n 0 340.01n 1
+ 370n 1 370.01n 0 380n 0 380.01n 1 390n 1 390.01n 0 400n 0 400.01n 1 410n 1 410.01n 0 420n 0
+ 420.01n 1 430n 1 430.01n 0 440n 0 440.01n 1 480n 1 480.01n 0 490n 0 490.01n 1 500n 1 500.01n 0
+ 510n 0 510.01n 1 530n 1 530.01n 0 540n 0 540.01n 1 560n 1 560.01n 0 580n 0 580.01n 1)
vg15 g15 0 pwl( 0 0 20n 0 20.01n 1 40n 1 40.01n 0 50n 0 50.01n 1 60n 1 60.01n 0 110n 0 110.01n 1
+ 130n 1 130.01n 0 170n 0 170.01n 1 180n 1 180.01n 0 270n 0 270.01n 1 280n 1 280.01n 0 300n 0
+ 300.01n 1 330n 1 330.01n 0 340n 0 340.01n 1 360n 1 360.01n 0 370n 0 370.01n 1 380n 1 380.01n 0
+ 390n 0 390.01n 1 400n 1 400.01n 0 420n 0 420.01n 1 440n 1 440.01n 0 450n 0 450.01n 1 460n 1
+ 460.01n 0 470n 0 470.01n 1 480n 1 480.01n 0 560n 0 560.01n 1 580n 1 580.01n 0 590n 0 590.01n 1
+ 610n 1 610.01n 0)
vg33 g33 0 pwl( 0 0 10n 0 10.01n 1 20n 1 20.01n 0 40n 0 40.01n 1 60n 1 60.01n 0 70n 0 70.01n 1 90n 1
+ 90.01n 0 100n 0 100.01n 1 120n 1 120.01n 0 140n 0 140.01n 1 150n 1 150.01n 0 180n 0 180.01n 1 270n
+ 1 270.01n 0 280n 0 280.01n 1 310n 1 310.01n 0 320n 0 320.01n 1 330n 1 330.01n 0 340n 0 340.01n 1
+ 350n 1 350.01n 0 360n 0 360.01n 1 390n 1 390.01n 0 400n 0 400.01n 1 430n 1 430.01n 0 460n 0
+ 460.01n 1 500n 1 500.01n 0 530n 0 530.01n 1 540n 1 540.01n 0 560n 0 560.01n 1 610n 1 610.01n 0
+ 630n 0 630.01n 1)
vg7 g7 0 pwl( 0 0 10n 0 10.01n 1 20n 1 20.01n 0 30n 0 30.01n 1 40n 1 40.01n 0 50n 0 50.01n 1 90n 1
+ 90.01n 0 140n 0 140.01n 1 180n 1 180.01n 0 190n 0 190.01n 1 220n 1 220.01n 0 230n 0 230.01n 1 250n
+ 1 250.01n 0 260n 0 260.01n 1 270n 1 270.01n 0 290n 0 290.01n 1 300n 1 300.01n 0 320n 0 320.01n 1
+ 350n 1 350.01n 0 360n 0 360.01n 1 390n 1 390.01n 0 400n 0 400.01n 1 470n 1 470.01n 0 480n 0
+ 480.01n 1 510n 1 510.01n 0 550n 0 550.01n 1 590n 1 590.01n 0 600n 0 600.01n 1)
vg34 g34 0 pwl( 0 0 10n 0 10.01n 1 50n 1 50.01n 0 80n 0 80.01n 1 110n 1 110.01n 0 140n 0 140.01n 1
+ 150n 1 150.01n 0 160n 0 160.01n 1 200n 1 200.01n 0 210n 0 210.01n 1 220n 1 220.01n 0 250n 0
+ 250.01n 1 280n 1 280.01n 0 290n 0 290.01n 1 310n 1 310.01n 0 340n 0 340.01n 1 400n 1 400.01n 0
+ 410n 0 410.01n 1 430n 1 430.01n 0 440n 0 440.01n 1 450n 1 450.01n 0 470n 0 470.01n 1 490n 1
+ 490.01n 0 520n 0 520.01n 1 550n 1 550.01n 0 590n 0 590.01n 1 620n 1 620.01n 0)
