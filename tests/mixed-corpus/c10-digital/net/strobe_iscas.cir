* C10 strobe for the ISCAS 1 ns runs (RSpice-authored): the event net d_stb rises
* at 45 ps (the inputs, rising from t = 0, are still below every threshold) and
* at 985 ps (the inputs high since 200 ps); the codes are read just before each rise.
vstb stb 0 pwl(0 0 40p 0 50p 1 60p 1 70p 0 980p 0 990p 1 1n 1)
astb [stb] [d_stb] adc_stb
.model adc_stb adc_bridge(in_low = 0.5 in_high = 0.5 rise_delay = 1e-12 fall_delay = 1e-12)
