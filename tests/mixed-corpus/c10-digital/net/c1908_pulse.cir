* C10 c1908 primary inputs, from tests/iscas85/85/c1908/c1908.net (ground spelled 0):
* every input rises 0 -> 1 V in 200 ps from t = 0.
v1 g21 0 pulse(0 1 0p 200p 200p 1n 2n)
v2 g18 0 pulse(0 1 0p 200p 200p 1n 2n)
v3 g32 0 pulse(0 1 0p 200p 200p 1n 2n)
v4 g30 0 pulse(0 1 0p 200p 200p 1n 2n)
v5 g12 0 pulse(0 1 0p 200p 200p 1n 2n)
v6 g24 0 pulse(0 1 0p 200p 200p 1n 2n)
v7 g5 0 pulse(0 1 0p 200p 200p 1n 2n)
v8 g9 0 pulse(0 1 0p 200p 200p 1n 2n)
v9 g14 0 pulse(0 1 0p 200p 200p 1n 2n)
v10 g3 0 pulse(0 1 0p 200p 200p 1n 2n)
v11 g26 0 pulse(0 1 0p 200p 200p 1n 2n)
v12 g10 0 pulse(0 1 0p 200p 200p 1n 2n)
v13 g15 0 pulse(0 1 0p 200p 200p 1n 2n)
v14 g7 0 pulse(0 1 0p 200p 200p 1n 2n)
v15 g31 0 pulse(0 1 0p 200p 200p 1n 2n)
v16 g17 0 pulse(0 1 0p 200p 200p 1n 2n)
v17 g27 0 pulse(0 1 0p 200p 200p 1n 2n)
v18 g11 0 pulse(0 1 0p 200p 200p 1n 2n)
v19 g22 0 pulse(0 1 0p 200p 200p 1n 2n)
v20 g4 0 pulse(0 1 0p 200p 200p 1n 2n)
v21 g29 0 pulse(0 1 0p 200p 200p 1n 2n)
v22 g20 0 pulse(0 1 0p 200p 200p 1n 2n)
v23 g23 0 pulse(0 1 0p 200p 200p 1n 2n)
v24 g13 0 pulse(0 1 0p 200p 200p 1n 2n)
v25 g2 0 pulse(0 1 0p 200p 200p 1n 2n)
v26 g19 0 pulse(0 1 0p 200p 200p 1n 2n)
v27 g8 0 pulse(0 1 0p 200p 200p 1n 2n)
v28 g16 0 pulse(0 1 0p 200p 200p 1n 2n)
v29 g6 0 pulse(0 1 0p 200p 200p 1n 2n)
v30 g1 0 pulse(0 1 0p 200p 200p 1n 2n)
v31 g28 0 pulse(0 1 0p 200p 200p 1n 2n)
v32 g25 0 pulse(0 1 0p 200p 200p 1n 2n)
v33 g33 0 pulse(0 1 0p 200p 200p 1n 2n)
