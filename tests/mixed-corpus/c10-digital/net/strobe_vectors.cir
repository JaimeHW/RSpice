* C10 strobe for the 64-vector runs (RSpice-authored): the event net d_stb rises
* 8 ns into each 10 ns vector; the codes are read just before each rise.
vstb stb 0 pulse(0 1 8n 10p 10p 1n 10n)
astb [stb] [d_stb] adc_stb
.model adc_stb adc_bridge(in_low = 0.5 in_high = 0.5 rise_delay = 1e-12 fall_delay = 1e-12)
