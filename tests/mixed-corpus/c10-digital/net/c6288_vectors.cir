* C10 c6288: 8 random input vectors (Python random.Random(1).getrandbits(1) per input,
* vector-major, inputs in deck order), one per 10 ns with 10 ps transitions.
vg21 g21 0 pwl( 0 0 30n 0 30.01n 1 40n 1 40.01n 0 50n 0 50.01n 1 70n 1 70.01n 0)
vg18 g18 0 pwl( 0 1 40n 1 40.01n 0 70n 0 70.01n 1)
vg30 g30 0 pwl( 0 1 20n 1 20.01n 0 30n 0 30.01n 1 40n 1 40.01n 0 50n 0 50.01n 1 70n 1 70.01n 0)
vg5 g5 0 pwl( 0 1 10n 1 10.01n 0 20n 0 20.01n 1 30n 1 30.01n 0 40n 0 40.01n 1)
vg14 g14 0 pwl( 0 1 20n 1 20.01n 0 40n 0 40.01n 1 70n 1 70.01n 0)
vg26 g26 0 pwl( 0 0 20n 0 20.01n 1 30n 1 30.01n 0 50n 0 50.01n 1 60n 1 60.01n 0 70n 0 70.01n 1)
vg15 g15 0 pwl( 0 0 30n 0 30.01n 1 50n 1 50.01n 0 70n 0 70.01n 1)
vg7 g7 0 pwl( 0 0 30n 0 30.01n 1 40n 1 40.01n 0 60n 0 60.01n 1 70n 1 70.01n 0)
vg17 g17 0 pwl( 0 0 20n 0 20.01n 1 60n 1 60.01n 0 70n 0 70.01n 1)
vg27 g27 0 pwl( 0 1 30n 1 30.01n 0 40n 0 40.01n 1 50n 1 50.01n 0)
vg22 g22 0 pwl( 0 0 10n 0 10.01n 1 40n 1 40.01n 0 50n 0 50.01n 1)
vg4 g4 0 pwl( 0 0 20n 0 20.01n 1 40n 1 40.01n 0 50n 0 50.01n 1 60n 1 60.01n 0 70n 0 70.01n 1)
vg23 g23 0 pwl( 0 1 40n 1 40.01n 0 50n 0 50.01n 1)
vg13 g13 0 pwl( 0 0 10n 0 10.01n 1 20n 1 20.01n 0 40n 0 40.01n 1 50n 1 50.01n 0 60n 0 60.01n 1)
vg19 g19 0 pwl( 0 1 10n 1 10.01n 0 30n 0 30.01n 1 40n 1 40.01n 0 70n 0 70.01n 1)
vg6 g6 0 pwl( 0 0 10n 0 10.01n 1 40n 1 40.01n 0 50n 0 50.01n 1)
vg1 g1 0 pwl( 0 0 20n 0 20.01n 1 30n 1 30.01n 0 60n 0 60.01n 1 70n 1 70.01n 0)
vg28 g28 0 pwl( 0 0 10n 0 10.01n 1 30n 1 30.01n 0 50n 0 50.01n 1 60n 1 60.01n 0)
vg32 g32 0 pwl( 0 0 20n 0 20.01n 1 30n 1 30.01n 0 40n 0 40.01n 1 60n 1 60.01n 0 70n 0 70.01n 1)
vg12 g12 0 pwl( 0 1 20n 1 20.01n 0 30n 0 30.01n 1)
vg24 g24 0 pwl( 0 1 10n 1 10.01n 0 30n 0 30.01n 1 60n 1 60.01n 0 70n 0 70.01n 1)
vg9 g9 0 pwl( 0 0 10n 0 10.01n 1 30n 1 30.01n 0 40n 0 40.01n 1 60n 1 60.01n 0)
vg3 g3 0 pwl( 0 0 40n 0 40.01n 1 50n 1 50.01n 0)
vg10 g10 0 pwl( 0 1 50n 1 50.01n 0 70n 0 70.01n 1)
vg31 g31 0 pwl( 0 1 10n 1 10.01n 0 20n 0 20.01n 1 30n 1 30.01n 0 50n 0 50.01n 1 70n 1 70.01n 0)
vg11 g11 0 pwl( 0 1 30n 1 30.01n 0 40n 0 40.01n 1 70n 1 70.01n 0)
vg29 g29 0 pwl( 0 0 20n 0 20.01n 1 40n 1 40.01n 0 50n 0 50.01n 1 70n 1 70.01n 0)
vg20 g20 0 pwl( 0 1 40n 1 40.01n 0 50n 0 50.01n 1)
vg2 g2 0 pwl( 0 0 20n 0 20.01n 1)
vg8 g8 0 pwl( 0 0 20n 0 20.01n 1 40n 1 40.01n 0 50n 0 50.01n 1 60n 1 60.01n 0)
vg16 g16 0 pwl( 0 1 10n 1 10.01n 0 30n 0 30.01n 1 60n 1 60.01n 0)
vg25 g25 0 pwl( 0 1 40n 1 40.01n 0 50n 0 50.01n 1 70n 1 70.01n 0)
