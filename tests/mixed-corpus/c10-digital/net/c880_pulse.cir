* C10 c880 primary inputs, from tests/iscas85/85/c880/c880.net (ground spelled 0):
* every input rises 0 -> 1 V in 200 ps from t = 0.
v1 g44 0 pulse(0 1 0p 200p 200p 1n 2n)
v2 g57 0 pulse(0 1 0p 200p 200p 1n 2n)
v3 g35 0 pulse(0 1 0p 200p 200p 1n 2n)
v4 g21 0 pulse(0 1 0p 200p 200p 1n 2n)
v5 g18 0 pulse(0 1 0p 200p 200p 1n 2n)
v6 g23 0 pulse(0 1 0p 200p 200p 1n 2n)
v7 g13 0 pulse(0 1 0p 200p 200p 1n 2n)
v8 g53 0 pulse(0 1 0p 200p 200p 1n 2n)
v9 g41 0 pulse(0 1 0p 200p 200p 1n 2n)
v10 g37 0 pulse(0 1 0p 200p 200p 1n 2n)
v11 g2 0 pulse(0 1 0p 200p 200p 1n 2n)
v12 g31 0 pulse(0 1 0p 200p 200p 1n 2n)
v13 g9 0 pulse(0 1 0p 200p 200p 1n 2n)
v14 g17 0 pulse(0 1 0p 200p 200p 1n 2n)
v15 g27 0 pulse(0 1 0p 200p 200p 1n 2n)
v16 g60 0 pulse(0 1 0p 200p 200p 1n 2n)
v17 g40 0 pulse(0 1 0p 200p 200p 1n 2n)
v18 g14 0 pulse(0 1 0p 200p 200p 1n 2n)
v19 g47 0 pulse(0 1 0p 200p 200p 1n 2n)
v20 g36 0 pulse(0 1 0p 200p 200p 1n 2n)
v21 g46 0 pulse(0 1 0p 200p 200p 1n 2n)
v22 g19 0 pulse(0 1 0p 200p 200p 1n 2n)
v23 g58 0 pulse(0 1 0p 200p 200p 1n 2n)
v24 g8 0 pulse(0 1 0p 200p 200p 1n 2n)
v25 g3 0 pulse(0 1 0p 200p 200p 1n 2n)
v26 g26 0 pulse(0 1 0p 200p 200p 1n 2n)
v27 g59 0 pulse(0 1 0p 200p 200p 1n 2n)
v28 g54 0 pulse(0 1 0p 200p 200p 1n 2n)
v29 g16 0 pulse(0 1 0p 200p 200p 1n 2n)
v30 g11 0 pulse(0 1 0p 200p 200p 1n 2n)
v31 g22 0 pulse(0 1 0p 200p 200p 1n 2n)
v32 g32 0 pulse(0 1 0p 200p 200p 1n 2n)
v33 g50 0 pulse(0 1 0p 200p 200p 1n 2n)
v34 g30 0 pulse(0 1 0p 200p 200p 1n 2n)
v35 g10 0 pulse(0 1 0p 200p 200p 1n 2n)
v36 g45 0 pulse(0 1 0p 200p 200p 1n 2n)
v37 g6 0 pulse(0 1 0p 200p 200p 1n 2n)
v38 g1 0 pulse(0 1 0p 200p 200p 1n 2n)
v39 g48 0 pulse(0 1 0p 200p 200p 1n 2n)
v40 g28 0 pulse(0 1 0p 200p 200p 1n 2n)
v41 g55 0 pulse(0 1 0p 200p 200p 1n 2n)
v42 g42 0 pulse(0 1 0p 200p 200p 1n 2n)
v43 g51 0 pulse(0 1 0p 200p 200p 1n 2n)
v44 g25 0 pulse(0 1 0p 200p 200p 1n 2n)
v45 g4 0 pulse(0 1 0p 200p 200p 1n 2n)
v46 g15 0 pulse(0 1 0p 200p 200p 1n 2n)
v47 g12 0 pulse(0 1 0p 200p 200p 1n 2n)
v48 g29 0 pulse(0 1 0p 200p 200p 1n 2n)
v49 g33 0 pulse(0 1 0p 200p 200p 1n 2n)
v50 g7 0 pulse(0 1 0p 200p 200p 1n 2n)
v51 g49 0 pulse(0 1 0p 200p 200p 1n 2n)
v52 g24 0 pulse(0 1 0p 200p 200p 1n 2n)
v53 g39 0 pulse(0 1 0p 200p 200p 1n 2n)
v54 g56 0 pulse(0 1 0p 200p 200p 1n 2n)
v55 g52 0 pulse(0 1 0p 200p 200p 1n 2n)
v56 g34 0 pulse(0 1 0p 200p 200p 1n 2n)
v57 g38 0 pulse(0 1 0p 200p 200p 1n 2n)
v58 g20 0 pulse(0 1 0p 200p 200p 1n 2n)
v59 g5 0 pulse(0 1 0p 200p 200p 1n 2n)
v60 g43 0 pulse(0 1 0p 200p 200p 1n 2n)
