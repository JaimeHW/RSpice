* C10 c1355 primary inputs, from tests/iscas85/85/c1355/c1355.net (ground spelled 0):
* every input rises 0 -> 1 V in 200 ps from t = 0.
v1 g21 0 pulse(0 1 0p 200p 200p 1n 2n)
v2 g18 0 pulse(0 1 0p 200p 200p 1n 2n)
v3 g31 0 pulse(0 1 0p 200p 200p 1n 2n)
v4 g17 0 pulse(0 1 0p 200p 200p 1n 2n)
v5 g27 0 pulse(0 1 0p 200p 200p 1n 2n)
v6 g11 0 pulse(0 1 0p 200p 200p 1n 2n)
v7 g22 0 pulse(0 1 0p 200p 200p 1n 2n)
v8 g32 0 pulse(0 1 0p 200p 200p 1n 2n)
v9 g30 0 pulse(0 1 0p 200p 200p 1n 2n)
v10 g4 0 pulse(0 1 0p 200p 200p 1n 2n)
v11 g12 0 pulse(0 1 0p 200p 200p 1n 2n)
v12 g29 0 pulse(0 1 0p 200p 200p 1n 2n)
v13 g24 0 pulse(0 1 0p 200p 200p 1n 2n)
v14 g39 0 pulse(0 1 0p 200p 200p 1n 2n)
v15 g38 0 pulse(0 1 0p 200p 200p 1n 2n)
v16 g20 0 pulse(0 1 0p 200p 200p 1n 2n)
v17 g5 0 pulse(0 1 0p 200p 200p 1n 2n)
v18 g35 0 pulse(0 1 0p 200p 200p 1n 2n)
v19 g23 0 pulse(0 1 0p 200p 200p 1n 2n)
v20 g13 0 pulse(0 1 0p 200p 200p 1n 2n)
v21 g2 0 pulse(0 1 0p 200p 200p 1n 2n)
v22 g37 0 pulse(0 1 0p 200p 200p 1n 2n)
v23 g41 0 pulse(0 1 0p 200p 200p 1n 2n)
v24 g9 0 pulse(0 1 0p 200p 200p 1n 2n)
v25 g40 0 pulse(0 1 0p 200p 200p 1n 2n)
v26 g14 0 pulse(0 1 0p 200p 200p 1n 2n)
v27 g36 0 pulse(0 1 0p 200p 200p 1n 2n)
v28 g19 0 pulse(0 1 0p 200p 200p 1n 2n)
v29 g8 0 pulse(0 1 0p 200p 200p 1n 2n)
v30 g3 0 pulse(0 1 0p 200p 200p 1n 2n)
v31 g26 0 pulse(0 1 0p 200p 200p 1n 2n)
v32 g16 0 pulse(0 1 0p 200p 200p 1n 2n)
v33 g10 0 pulse(0 1 0p 200p 200p 1n 2n)
v34 g6 0 pulse(0 1 0p 200p 200p 1n 2n)
v35 g1 0 pulse(0 1 0p 200p 200p 1n 2n)
v36 g28 0 pulse(0 1 0p 200p 200p 1n 2n)
v37 g25 0 pulse(0 1 0p 200p 200p 1n 2n)
v38 g15 0 pulse(0 1 0p 200p 200p 1n 2n)
v39 g33 0 pulse(0 1 0p 200p 200p 1n 2n)
v40 g7 0 pulse(0 1 0p 200p 200p 1n 2n)
v41 g34 0 pulse(0 1 0p 200p 200p 1n 2n)
