* C10 c1355, tran-vec: O1 (ngspice-46) vector replay. The ISCAS85 transistor-level
* deck tests/iscas85/85/c1355/c1355.net (45 nm BSIM4 PTM, Vdd 1.8 V) included verbatim,
* plus the vector runs' strobe and the tran O1 deck's A/D probes at 0.9 V (Vdd/2) on
* the primary outputs, named as the xs digital nets. The control script re-points
* every input source at the 64 random vectors of net/c1355_vectors.cir (the
* RSpice decks' PWL, one vector per 10 ns, 10 ps transitions) swung 0 -> 1.8 V as
* the tran O1 decks swing them, and runs the vector span; the outputs are read
* 8 ns into each vector at the strobe. This checks the gate-level conversion
* against the transistor netlist independently of the O6 expectation.
.include ../../../iscas85/85/c1355/c1355.net
.include ../net/strobe_vectors.cir
aprobe [g1324 g1325 g1326 g1327 g1328 g1329 g1330 g1331 g1332 g1333 g1334 g1335 g1336 g1337 g1338
+ g1339 g1340 g1341 g1342 g1343 g1344 g1345 g1346 g1347 g1348 g1349 g1350 g1351 g1352 g1353 g1354
+ g1355] [d_g1324 d_g1325 d_g1326 d_g1327 d_g1328 d_g1329 d_g1330 d_g1331 d_g1332 d_g1333 d_g1334
+ d_g1335 d_g1336 d_g1337 d_g1338 d_g1339 d_g1340 d_g1341 d_g1342 d_g1343 d_g1344 d_g1345 d_g1346
+ d_g1347 d_g1348 d_g1349 d_g1350 d_g1351 d_g1352 d_g1353 d_g1354 d_g1355] adc_logic
.model adc_logic adc_bridge(in_low = 0.9 in_high = 0.9 rise_delay = 1e-12 fall_delay = 1e-12)
* rspice-write: v(g1324)
* rspice-stochastic: ngspice-46 does not reproduce these transistor-level replays' analog tables byte for byte from one capture to the next (seen on c499 and c6288 with the same deck and executable); the output events the vector codes are read from reproduce exactly
* rspice-events: d_stb d_g1324 d_g1325 d_g1326 d_g1327 d_g1328 d_g1329 d_g1330 d_g1331 d_g1332 d_g1333 d_g1334 d_g1335 d_g1336 d_g1337 d_g1338 d_g1339 d_g1340 d_g1341 d_g1342 d_g1343 d_g1344 d_g1345 d_g1346 d_g1347 d_g1348 d_g1349 d_g1350 d_g1351 d_g1352 d_g1353 d_g1354 d_g1355
* rspice-control-begin
* alter @v1[pwl] = [ 0 0 10n 0 10.01n 1.8 60n 1.8 60.01n 0 110n 0 110.01n 1.8 130n 1.8 130.01n 0 170n 0 170.01n 1.8 180n 1.8 180.01n 0 190n 0 190.01n 1.8 210n 1.8 210.01n 0 240n 0 240.01n 1.8 250n 1.8 250.01n 0 280n 0 280.01n 1.8 290n 1.8 290.01n 0 300n 0 300.01n 1.8 350n 1.8 350.01n 0 360n 0 360.01n 1.8 370n 1.8 370.01n 0 420n 0 420.01n 1.8 450n 1.8 450.01n 0 470n 0 470.01n 1.8 520n 1.8 520.01n 0 530n 0 530.01n 1.8 540n 1.8 540.01n 0 550n 0 550.01n 1.8 560n 1.8 560.01n 0 590n 0 590.01n 1.8 600n 1.8 600.01n 0 ]
* alter @v2[pwl] = [ 0 1.8 20n 1.8 20.01n 0 30n 0 30.01n 1.8 50n 1.8 50.01n 0 60n 0 60.01n 1.8 70n 1.8 70.01n 0 80n 0 80.01n 1.8 90n 1.8 90.01n 0 100n 0 100.01n 1.8 130n 1.8 130.01n 0 150n 0 150.01n 1.8 170n 1.8 170.01n 0 190n 0 190.01n 1.8 200n 1.8 200.01n 0 210n 0 210.01n 1.8 220n 1.8 220.01n 0 260n 0 260.01n 1.8 270n 1.8 270.01n 0 290n 0 290.01n 1.8 300n 1.8 300.01n 0 400n 0 400.01n 1.8 430n 1.8 430.01n 0 450n 0 450.01n 1.8 460n 1.8 460.01n 0 480n 0 480.01n 1.8 510n 1.8 510.01n 0 520n 0 520.01n 1.8 540n 1.8 540.01n 0 570n 0 570.01n 1.8 580n 1.8 580.01n 0 620n 0 620.01n 1.8 ]
* alter @v3[pwl] = [ 0 1.8 10n 1.8 10.01n 0 30n 0 30.01n 1.8 40n 1.8 40.01n 0 50n 0 50.01n 1.8 60n 1.8 60.01n 0 80n 0 80.01n 1.8 110n 1.8 110.01n 0 130n 0 130.01n 1.8 150n 1.8 150.01n 0 160n 0 160.01n 1.8 180n 1.8 180.01n 0 190n 0 190.01n 1.8 200n 1.8 200.01n 0 210n 0 210.01n 1.8 220n 1.8 220.01n 0 240n 0 240.01n 1.8 260n 1.8 260.01n 0 270n 0 270.01n 1.8 290n 1.8 290.01n 0 300n 0 300.01n 1.8 320n 1.8 320.01n 0 340n 0 340.01n 1.8 350n 1.8 350.01n 0 400n 0 400.01n 1.8 410n 1.8 410.01n 0 420n 0 420.01n 1.8 440n 1.8 440.01n 0 460n 0 460.01n 1.8 470n 1.8 470.01n 0 500n 0 500.01n 1.8 520n 1.8 520.01n 0 530n 0 530.01n 1.8 590n 1.8 590.01n 0 600n 0 600.01n 1.8 610n 1.8 610.01n 0 ]
* alter @v4[pwl] = [ 0 1.8 40n 1.8 40.01n 0 50n 0 50.01n 1.8 60n 1.8 60.01n 0 70n 0 70.01n 1.8 110n 1.8 110.01n 0 120n 0 120.01n 1.8 130n 1.8 130.01n 0 180n 0 180.01n 1.8 190n 1.8 190.01n 0 220n 0 220.01n 1.8 250n 1.8 250.01n 0 290n 0 290.01n 1.8 310n 1.8 310.01n 0 340n 0 340.01n 1.8 360n 1.8 360.01n 0 370n 0 370.01n 1.8 380n 1.8 380.01n 0 390n 0 390.01n 1.8 420n 1.8 420.01n 0 430n 0 430.01n 1.8 440n 1.8 440.01n 0 450n 0 450.01n 1.8 520n 1.8 520.01n 0 530n 0 530.01n 1.8 550n 1.8 550.01n 0 600n 0 600.01n 1.8 620n 1.8 620.01n 0 630n 0 630.01n 1.8 ]
* alter @v5[pwl] = [ 0 1.8 20n 1.8 20.01n 0 30n 0 30.01n 1.8 50n 1.8 50.01n 0 70n 0 70.01n 1.8 80n 1.8 80.01n 0 90n 0 90.01n 1.8 110n 1.8 110.01n 0 140n 0 140.01n 1.8 160n 1.8 160.01n 0 170n 0 170.01n 1.8 180n 1.8 180.01n 0 190n 0 190.01n 1.8 220n 1.8 220.01n 0 240n 0 240.01n 1.8 280n 1.8 280.01n 0 290n 0 290.01n 1.8 300n 1.8 300.01n 0 320n 0 320.01n 1.8 330n 1.8 330.01n 0 360n 0 360.01n 1.8 380n 1.8 380.01n 0 430n 0 430.01n 1.8 440n 1.8 440.01n 0 460n 0 460.01n 1.8 470n 1.8 470.01n 0 490n 0 490.01n 1.8 510n 1.8 510.01n 0 540n 0 540.01n 1.8 550n 1.8 550.01n 0 570n 0 570.01n 1.8 610n 1.8 610.01n 0 620n 0 620.01n 1.8 630n 1.8 630.01n 0 ]
* alter @v6[pwl] = [ 0 0 20n 0 20.01n 1.8 30n 1.8 30.01n 0 60n 0 60.01n 1.8 100n 1.8 100.01n 0 120n 0 120.01n 1.8 150n 1.8 150.01n 0 170n 0 170.01n 1.8 180n 1.8 180.01n 0 190n 0 190.01n 1.8 200n 1.8 200.01n 0 210n 0 210.01n 1.8 220n 1.8 220.01n 0 240n 0 240.01n 1.8 250n 1.8 250.01n 0 260n 0 260.01n 1.8 290n 1.8 290.01n 0 310n 0 310.01n 1.8 320n 1.8 320.01n 0 390n 0 390.01n 1.8 420n 1.8 420.01n 0 490n 0 490.01n 1.8 500n 1.8 500.01n 0 530n 0 530.01n 1.8 540n 1.8 540.01n 0 580n 0 580.01n 1.8 600n 1.8 600.01n 0 610n 0 610.01n 1.8 ]
* alter @v7[pwl] = [ 0 0 10n 0 10.01n 1.8 30n 1.8 30.01n 0 40n 0 40.01n 1.8 100n 1.8 100.01n 0 130n 0 130.01n 1.8 150n 1.8 150.01n 0 160n 0 160.01n 1.8 180n 1.8 180.01n 0 190n 0 190.01n 1.8 220n 1.8 220.01n 0 240n 0 240.01n 1.8 270n 1.8 270.01n 0 290n 0 290.01n 1.8 340n 1.8 340.01n 0 370n 0 370.01n 1.8 380n 1.8 380.01n 0 390n 0 390.01n 1.8 400n 1.8 400.01n 0 410n 0 410.01n 1.8 430n 1.8 430.01n 0 440n 0 440.01n 1.8 450n 1.8 450.01n 0 460n 0 460.01n 1.8 480n 1.8 480.01n 0 490n 0 490.01n 1.8 500n 1.8 500.01n 0 510n 0 510.01n 1.8 520n 1.8 520.01n 0 540n 0 540.01n 1.8 560n 1.8 560.01n 0 590n 0 590.01n 1.8 610n 1.8 610.01n 0 630n 0 630.01n 1.8 ]
* alter @v8[pwl] = [ 0 0 20n 0 20.01n 1.8 30n 1.8 30.01n 0 40n 0 40.01n 1.8 50n 1.8 50.01n 0 90n 0 90.01n 1.8 100n 1.8 100.01n 0 160n 0 160.01n 1.8 180n 1.8 180.01n 0 190n 0 190.01n 1.8 210n 1.8 210.01n 0 220n 0 220.01n 1.8 280n 1.8 280.01n 0 310n 0 310.01n 1.8 320n 1.8 320.01n 0 330n 0 330.01n 1.8 360n 1.8 360.01n 0 370n 0 370.01n 1.8 430n 1.8 430.01n 0 440n 0 440.01n 1.8 460n 1.8 460.01n 0 470n 0 470.01n 1.8 490n 1.8 490.01n 0 500n 0 500.01n 1.8 510n 1.8 510.01n 0 520n 0 520.01n 1.8 600n 1.8 600.01n 0 630n 0 630.01n 1.8 ]
* alter @v9[pwl] = [ 0 0 10n 0 10.01n 1.8 50n 1.8 50.01n 0 70n 0 70.01n 1.8 80n 1.8 80.01n 0 90n 0 90.01n 1.8 100n 1.8 100.01n 0 120n 0 120.01n 1.8 130n 1.8 130.01n 0 170n 0 170.01n 1.8 180n 1.8 180.01n 0 210n 0 210.01n 1.8 240n 1.8 240.01n 0 250n 0 250.01n 1.8 290n 1.8 290.01n 0 310n 0 310.01n 1.8 330n 1.8 330.01n 0 340n 0 340.01n 1.8 350n 1.8 350.01n 0 370n 0 370.01n 1.8 390n 1.8 390.01n 0 400n 0 400.01n 1.8 410n 1.8 410.01n 0 450n 0 450.01n 1.8 470n 1.8 470.01n 0 480n 0 480.01n 1.8 500n 1.8 500.01n 0 530n 0 530.01n 1.8 550n 1.8 550.01n 0 580n 0 580.01n 1.8 600n 1.8 600.01n 0 ]
* alter @v10[pwl] = [ 0 1.8 10n 1.8 10.01n 0 20n 0 20.01n 1.8 40n 1.8 40.01n 0 70n 0 70.01n 1.8 100n 1.8 100.01n 0 110n 0 110.01n 1.8 120n 1.8 120.01n 0 130n 0 130.01n 1.8 140n 1.8 140.01n 0 170n 0 170.01n 1.8 190n 1.8 190.01n 0 210n 0 210.01n 1.8 220n 1.8 220.01n 0 250n 0 250.01n 1.8 280n 1.8 280.01n 0 290n 0 290.01n 1.8 320n 1.8 320.01n 0 330n 0 330.01n 1.8 410n 1.8 410.01n 0 430n 0 430.01n 1.8 450n 1.8 450.01n 0 470n 0 470.01n 1.8 490n 1.8 490.01n 0 510n 0 510.01n 1.8 520n 1.8 520.01n 0 540n 0 540.01n 1.8 550n 1.8 550.01n 0 560n 0 560.01n 1.8 590n 1.8 590.01n 0 610n 0 610.01n 1.8 ]
* alter @v11[pwl] = [ 0 0 10n 0 10.01n 1.8 30n 1.8 30.01n 0 100n 0 100.01n 1.8 140n 1.8 140.01n 0 150n 0 150.01n 1.8 190n 1.8 190.01n 0 200n 0 200.01n 1.8 210n 1.8 210.01n 0 220n 0 220.01n 1.8 270n 1.8 270.01n 0 290n 0 290.01n 1.8 300n 1.8 300.01n 0 310n 0 310.01n 1.8 320n 1.8 320.01n 0 340n 0 340.01n 1.8 350n 1.8 350.01n 0 370n 0 370.01n 1.8 390n 1.8 390.01n 0 440n 0 440.01n 1.8 450n 1.8 450.01n 0 480n 0 480.01n 1.8 490n 1.8 490.01n 0 510n 0 510.01n 1.8 530n 1.8 530.01n 0 540n 0 540.01n 1.8 550n 1.8 550.01n 0 560n 0 560.01n 1.8 580n 1.8 580.01n 0 ]
* alter @v12[pwl] = [ 0 0 20n 0 20.01n 1.8 80n 1.8 80.01n 0 110n 0 110.01n 1.8 130n 1.8 130.01n 0 140n 0 140.01n 1.8 190n 1.8 190.01n 0 200n 0 200.01n 1.8 220n 1.8 220.01n 0 230n 0 230.01n 1.8 240n 1.8 240.01n 0 250n 0 250.01n 1.8 270n 1.8 270.01n 0 290n 0 290.01n 1.8 320n 1.8 320.01n 0 350n 0 350.01n 1.8 360n 1.8 360.01n 0 370n 0 370.01n 1.8 380n 1.8 380.01n 0 390n 0 390.01n 1.8 460n 1.8 460.01n 0 510n 0 510.01n 1.8 570n 1.8 570.01n 0 580n 0 580.01n 1.8 590n 1.8 590.01n 0 600n 0 600.01n 1.8 620n 1.8 620.01n 0 ]
* alter @v13[pwl] = [ 0 1.8 20n 1.8 20.01n 0 50n 0 50.01n 1.8 90n 1.8 90.01n 0 100n 0 100.01n 1.8 180n 1.8 180.01n 0 190n 0 190.01n 1.8 210n 1.8 210.01n 0 240n 0 240.01n 1.8 270n 1.8 270.01n 0 300n 0 300.01n 1.8 310n 1.8 310.01n 0 320n 0 320.01n 1.8 340n 1.8 340.01n 0 360n 0 360.01n 1.8 400n 1.8 400.01n 0 450n 0 450.01n 1.8 490n 1.8 490.01n 0 510n 0 510.01n 1.8 530n 1.8 530.01n 0 540n 0 540.01n 1.8 560n 1.8 560.01n 0 600n 0 600.01n 1.8 ]
* alter @v14[pwl] = [ 0 0 20n 0 20.01n 1.8 60n 1.8 60.01n 0 110n 0 110.01n 1.8 120n 1.8 120.01n 0 130n 0 130.01n 1.8 160n 1.8 160.01n 0 170n 0 170.01n 1.8 190n 1.8 190.01n 0 210n 0 210.01n 1.8 220n 1.8 220.01n 0 230n 0 230.01n 1.8 260n 1.8 260.01n 0 270n 0 270.01n 1.8 300n 1.8 300.01n 0 370n 0 370.01n 1.8 380n 1.8 380.01n 0 390n 0 390.01n 1.8 400n 1.8 400.01n 0 410n 0 410.01n 1.8 450n 1.8 450.01n 0 460n 0 460.01n 1.8 510n 1.8 510.01n 0 520n 0 520.01n 1.8 620n 1.8 620.01n 0 ]
* alter @v15[pwl] = [ 0 1.8 60n 1.8 60.01n 0 80n 0 80.01n 1.8 90n 1.8 90.01n 0 100n 0 100.01n 1.8 120n 1.8 120.01n 0 130n 0 130.01n 1.8 160n 1.8 160.01n 0 170n 0 170.01n 1.8 210n 1.8 210.01n 0 220n 0 220.01n 1.8 240n 1.8 240.01n 0 280n 0 280.01n 1.8 300n 1.8 300.01n 0 310n 0 310.01n 1.8 360n 1.8 360.01n 0 370n 0 370.01n 1.8 380n 1.8 380.01n 0 410n 0 410.01n 1.8 440n 1.8 440.01n 0 450n 0 450.01n 1.8 470n 1.8 470.01n 0 480n 0 480.01n 1.8 490n 1.8 490.01n 0 550n 0 550.01n 1.8 560n 1.8 560.01n 0 570n 0 570.01n 1.8 590n 1.8 590.01n 0 600n 0 600.01n 1.8 610n 1.8 610.01n 0 620n 0 620.01n 1.8 630n 1.8 630.01n 0 ]
* alter @v16[pwl] = [ 0 0 20n 0 20.01n 1.8 30n 1.8 30.01n 0 40n 0 40.01n 1.8 60n 1.8 60.01n 0 100n 0 100.01n 1.8 150n 1.8 150.01n 0 160n 0 160.01n 1.8 180n 1.8 180.01n 0 220n 0 220.01n 1.8 240n 1.8 240.01n 0 250n 0 250.01n 1.8 270n 1.8 270.01n 0 280n 0 280.01n 1.8 290n 1.8 290.01n 0 310n 0 310.01n 1.8 320n 1.8 320.01n 0 330n 0 330.01n 1.8 350n 1.8 350.01n 0 360n 0 360.01n 1.8 380n 1.8 380.01n 0 410n 0 410.01n 1.8 440n 1.8 440.01n 0 450n 0 450.01n 1.8 470n 1.8 470.01n 0 480n 0 480.01n 1.8 490n 1.8 490.01n 0 500n 0 500.01n 1.8 520n 1.8 520.01n 0 530n 0 530.01n 1.8 570n 1.8 570.01n 0 590n 0 590.01n 1.8 630n 1.8 630.01n 0 ]
* alter @v17[pwl] = [ 0 0 10n 0 10.01n 1.8 30n 1.8 30.01n 0 40n 0 40.01n 1.8 50n 1.8 50.01n 0 90n 0 90.01n 1.8 100n 1.8 100.01n 0 130n 0 130.01n 1.8 150n 1.8 150.01n 0 160n 0 160.01n 1.8 170n 1.8 170.01n 0 190n 0 190.01n 1.8 220n 1.8 220.01n 0 230n 0 230.01n 1.8 270n 1.8 270.01n 0 280n 0 280.01n 1.8 310n 1.8 310.01n 0 340n 0 340.01n 1.8 360n 1.8 360.01n 0 380n 0 380.01n 1.8 410n 1.8 410.01n 0 430n 0 430.01n 1.8 440n 1.8 440.01n 0 510n 0 510.01n 1.8 530n 1.8 530.01n 0 550n 0 550.01n 1.8 560n 1.8 560.01n 0 580n 0 580.01n 1.8 590n 1.8 590.01n 0 600n 0 600.01n 1.8 630n 1.8 630.01n 0 ]
* alter @v18[pwl] = [ 0 0 40n 0 40.01n 1.8 50n 1.8 50.01n 0 90n 0 90.01n 1.8 110n 1.8 110.01n 0 140n 0 140.01n 1.8 150n 1.8 150.01n 0 160n 0 160.01n 1.8 170n 1.8 170.01n 0 180n 0 180.01n 1.8 190n 1.8 190.01n 0 210n 0 210.01n 1.8 250n 1.8 250.01n 0 280n 0 280.01n 1.8 300n 1.8 300.01n 0 320n 0 320.01n 1.8 330n 1.8 330.01n 0 340n 0 340.01n 1.8 360n 1.8 360.01n 0 370n 0 370.01n 1.8 430n 1.8 430.01n 0 440n 0 440.01n 1.8 470n 1.8 470.01n 0 510n 0 510.01n 1.8 520n 1.8 520.01n 0 560n 0 560.01n 1.8 600n 1.8 600.01n 0 610n 0 610.01n 1.8 630n 1.8 630.01n 0 ]
* alter @v19[pwl] = [ 0 0 10n 0 10.01n 1.8 20n 1.8 20.01n 0 30n 0 30.01n 1.8 40n 1.8 40.01n 0 50n 0 50.01n 1.8 60n 1.8 60.01n 0 80n 0 80.01n 1.8 150n 1.8 150.01n 0 200n 0 200.01n 1.8 210n 1.8 210.01n 0 250n 0 250.01n 1.8 280n 1.8 280.01n 0 290n 0 290.01n 1.8 300n 1.8 300.01n 0 310n 0 310.01n 1.8 320n 1.8 320.01n 0 330n 0 330.01n 1.8 380n 1.8 380.01n 0 390n 0 390.01n 1.8 410n 1.8 410.01n 0 460n 0 460.01n 1.8 490n 1.8 490.01n 0 530n 0 530.01n 1.8 560n 1.8 560.01n 0 570n 0 570.01n 1.8 580n 1.8 580.01n 0 600n 0 600.01n 1.8 620n 1.8 620.01n 0 ]
* alter @v20[pwl] = [ 0 1.8 10n 1.8 10.01n 0 70n 0 70.01n 1.8 80n 1.8 80.01n 0 100n 0 100.01n 1.8 120n 1.8 120.01n 0 150n 0 150.01n 1.8 160n 1.8 160.01n 0 180n 0 180.01n 1.8 270n 1.8 270.01n 0 290n 0 290.01n 1.8 300n 1.8 300.01n 0 310n 0 310.01n 1.8 330n 1.8 330.01n 0 340n 0 340.01n 1.8 350n 1.8 350.01n 0 370n 0 370.01n 1.8 440n 1.8 440.01n 0 460n 0 460.01n 1.8 490n 1.8 490.01n 0 500n 0 500.01n 1.8 510n 1.8 510.01n 0 530n 0 530.01n 1.8 540n 1.8 540.01n 0 550n 0 550.01n 1.8 580n 1.8 580.01n 0 590n 0 590.01n 1.8 630n 1.8 630.01n 0 ]
* alter @v21[pwl] = [ 0 1.8 10n 1.8 10.01n 0 20n 0 20.01n 1.8 30n 1.8 30.01n 0 40n 0 40.01n 1.8 80n 1.8 80.01n 0 90n 0 90.01n 1.8 180n 1.8 180.01n 0 190n 0 190.01n 1.8 220n 1.8 220.01n 0 240n 0 240.01n 1.8 270n 1.8 270.01n 0 280n 0 280.01n 1.8 290n 1.8 290.01n 0 300n 0 300.01n 1.8 310n 1.8 310.01n 0 320n 0 320.01n 1.8 340n 1.8 340.01n 0 350n 0 350.01n 1.8 380n 1.8 380.01n 0 470n 0 470.01n 1.8 480n 1.8 480.01n 0 490n 0 490.01n 1.8 510n 1.8 510.01n 0 520n 0 520.01n 1.8 530n 1.8 530.01n 0 560n 0 560.01n 1.8 590n 1.8 590.01n 0 610n 0 610.01n 1.8 ]
* alter @v22[pwl] = [ 0 0 20n 0 20.01n 1.8 30n 1.8 30.01n 0 40n 0 40.01n 1.8 50n 1.8 50.01n 0 60n 0 60.01n 1.8 70n 1.8 70.01n 0 80n 0 80.01n 1.8 90n 1.8 90.01n 0 100n 0 100.01n 1.8 110n 1.8 110.01n 0 150n 0 150.01n 1.8 160n 1.8 160.01n 0 180n 0 180.01n 1.8 210n 1.8 210.01n 0 270n 0 270.01n 1.8 290n 1.8 290.01n 0 340n 0 340.01n 1.8 350n 1.8 350.01n 0 380n 0 380.01n 1.8 390n 1.8 390.01n 0 400n 0 400.01n 1.8 440n 1.8 440.01n 0 460n 0 460.01n 1.8 470n 1.8 470.01n 0 500n 0 500.01n 1.8 510n 1.8 510.01n 0 520n 0 520.01n 1.8 530n 1.8 530.01n 0 550n 0 550.01n 1.8 580n 1.8 580.01n 0 600n 0 600.01n 1.8 630n 1.8 630.01n 0 ]
* alter @v23[pwl] = [ 0 0 10n 0 10.01n 1.8 30n 1.8 30.01n 0 40n 0 40.01n 1.8 60n 1.8 60.01n 0 80n 0 80.01n 1.8 90n 1.8 90.01n 0 150n 0 150.01n 1.8 170n 1.8 170.01n 0 190n 0 190.01n 1.8 220n 1.8 220.01n 0 250n 0 250.01n 1.8 270n 1.8 270.01n 0 280n 0 280.01n 1.8 310n 1.8 310.01n 0 320n 0 320.01n 1.8 330n 1.8 330.01n 0 360n 0 360.01n 1.8 380n 1.8 380.01n 0 410n 0 410.01n 1.8 430n 1.8 430.01n 0 460n 0 460.01n 1.8 470n 1.8 470.01n 0 480n 0 480.01n 1.8 490n 1.8 490.01n 0 500n 0 500.01n 1.8 510n 1.8 510.01n 0 540n 0 540.01n 1.8 560n 1.8 560.01n 0 570n 0 570.01n 1.8 580n 1.8 580.01n 0 ]
* alter @v24[pwl] = [ 0 1.8 10n 1.8 10.01n 0 30n 0 30.01n 1.8 50n 1.8 50.01n 0 60n 0 60.01n 1.8 80n 1.8 80.01n 0 100n 0 100.01n 1.8 110n 1.8 110.01n 0 120n 0 120.01n 1.8 130n 1.8 130.01n 0 150n 0 150.01n 1.8 160n 1.8 160.01n 0 170n 0 170.01n 1.8 180n 1.8 180.01n 0 190n 0 190.01n 1.8 200n 1.8 200.01n 0 210n 0 210.01n 1.8 220n 1.8 220.01n 0 230n 0 230.01n 1.8 240n 1.8 240.01n 0 250n 0 250.01n 1.8 260n 1.8 260.01n 0 270n 0 270.01n 1.8 280n 1.8 280.01n 0 300n 0 300.01n 1.8 310n 1.8 310.01n 0 340n 0 340.01n 1.8 370n 1.8 370.01n 0 400n 0 400.01n 1.8 440n 1.8 440.01n 0 450n 0 450.01n 1.8 490n 1.8 490.01n 0 520n 0 520.01n 1.8 530n 1.8 530.01n 0 540n 0 540.01n 1.8 570n 1.8 570.01n 0 580n 0 580.01n 1.8 590n 1.8 590.01n 0 600n 0 600.01n 1.8 610n 1.8 610.01n 0 620n 0 620.01n 1.8 630n 1.8 630.01n 0 ]
* alter @v25[pwl] = [ 0 1.8 60n 1.8 60.01n 0 70n 0 70.01n 1.8 110n 1.8 110.01n 0 120n 0 120.01n 1.8 130n 1.8 130.01n 0 140n 0 140.01n 1.8 150n 1.8 150.01n 0 160n 0 160.01n 1.8 180n 1.8 180.01n 0 190n 0 190.01n 1.8 200n 1.8 200.01n 0 210n 0 210.01n 1.8 230n 1.8 230.01n 0 250n 0 250.01n 1.8 260n 1.8 260.01n 0 270n 0 270.01n 1.8 280n 1.8 280.01n 0 290n 0 290.01n 1.8 300n 1.8 300.01n 0 380n 0 380.01n 1.8 440n 1.8 440.01n 0 480n 0 480.01n 1.8 490n 1.8 490.01n 0 500n 0 500.01n 1.8 510n 1.8 510.01n 0 520n 0 520.01n 1.8 540n 1.8 540.01n 0 570n 0 570.01n 1.8 590n 1.8 590.01n 0 600n 0 600.01n 1.8 610n 1.8 610.01n 0 620n 0 620.01n 1.8 ]
* alter @v26[pwl] = [ 0 1.8 10n 1.8 10.01n 0 20n 0 20.01n 1.8 80n 1.8 80.01n 0 90n 0 90.01n 1.8 110n 1.8 110.01n 0 130n 0 130.01n 1.8 140n 1.8 140.01n 0 160n 0 160.01n 1.8 190n 1.8 190.01n 0 210n 0 210.01n 1.8 270n 1.8 270.01n 0 290n 0 290.01n 1.8 300n 1.8 300.01n 0 340n 0 340.01n 1.8 350n 1.8 350.01n 0 390n 0 390.01n 1.8 400n 1.8 400.01n 0 430n 0 430.01n 1.8 450n 1.8 450.01n 0 460n 0 460.01n 1.8 470n 1.8 470.01n 0 490n 0 490.01n 1.8 500n 1.8 500.01n 0 540n 0 540.01n 1.8 550n 1.8 550.01n 0 560n 0 560.01n 1.8 570n 1.8 570.01n 0 580n 0 580.01n 1.8 590n 1.8 590.01n 0 610n 0 610.01n 1.8 630n 1.8 630.01n 0 ]
* alter @v27[pwl] = [ 0 0 10n 0 10.01n 1.8 50n 1.8 50.01n 0 60n 0 60.01n 1.8 70n 1.8 70.01n 0 180n 0 180.01n 1.8 200n 1.8 200.01n 0 210n 0 210.01n 1.8 220n 1.8 220.01n 0 250n 0 250.01n 1.8 270n 1.8 270.01n 0 280n 0 280.01n 1.8 290n 1.8 290.01n 0 320n 0 320.01n 1.8 330n 1.8 330.01n 0 400n 0 400.01n 1.8 410n 1.8 410.01n 0 420n 0 420.01n 1.8 430n 1.8 430.01n 0 450n 0 450.01n 1.8 460n 1.8 460.01n 0 470n 0 470.01n 1.8 480n 1.8 480.01n 0 490n 0 490.01n 1.8 520n 1.8 520.01n 0 540n 0 540.01n 1.8 570n 1.8 570.01n 0 590n 0 590.01n 1.8 610n 1.8 610.01n 0 630n 0 630.01n 1.8 ]
* alter @v28[pwl] = [ 0 1.8 10n 1.8 10.01n 0 30n 0 30.01n 1.8 60n 1.8 60.01n 0 70n 0 70.01n 1.8 90n 1.8 90.01n 0 110n 0 110.01n 1.8 120n 1.8 120.01n 0 190n 0 190.01n 1.8 200n 1.8 200.01n 0 210n 0 210.01n 1.8 240n 1.8 240.01n 0 280n 0 280.01n 1.8 300n 1.8 300.01n 0 320n 0 320.01n 1.8 380n 1.8 380.01n 0 390n 0 390.01n 1.8 410n 1.8 410.01n 0 420n 0 420.01n 1.8 430n 1.8 430.01n 0 440n 0 440.01n 1.8 450n 1.8 450.01n 0 460n 0 460.01n 1.8 490n 1.8 490.01n 0 510n 0 510.01n 1.8 570n 1.8 570.01n 0 620n 0 620.01n 1.8 630n 1.8 630.01n 0 ]
* alter @v29[pwl] = [ 0 0 10n 0 10.01n 1.8 50n 1.8 50.01n 0 70n 0 70.01n 1.8 80n 1.8 80.01n 0 90n 0 90.01n 1.8 120n 1.8 120.01n 0 150n 0 150.01n 1.8 160n 1.8 160.01n 0 170n 0 170.01n 1.8 180n 1.8 180.01n 0 210n 0 210.01n 1.8 220n 1.8 220.01n 0 230n 0 230.01n 1.8 240n 1.8 240.01n 0 250n 0 250.01n 1.8 270n 1.8 270.01n 0 280n 0 280.01n 1.8 290n 1.8 290.01n 0 310n 0 310.01n 1.8 330n 1.8 330.01n 0 340n 0 340.01n 1.8 350n 1.8 350.01n 0 380n 0 380.01n 1.8 400n 1.8 400.01n 0 420n 0 420.01n 1.8 430n 1.8 430.01n 0 470n 0 470.01n 1.8 480n 1.8 480.01n 0 490n 0 490.01n 1.8 500n 1.8 500.01n 0 520n 0 520.01n 1.8 530n 1.8 530.01n 0 550n 0 550.01n 1.8 570n 1.8 570.01n 0 580n 0 580.01n 1.8 620n 1.8 620.01n 0 ]
* alter @v30[pwl] = [ 0 0 20n 0 20.01n 1.8 30n 1.8 30.01n 0 50n 0 50.01n 1.8 70n 1.8 70.01n 0 110n 0 110.01n 1.8 130n 1.8 130.01n 0 160n 0 160.01n 1.8 170n 1.8 170.01n 0 180n 0 180.01n 1.8 190n 1.8 190.01n 0 200n 0 200.01n 1.8 230n 1.8 230.01n 0 240n 0 240.01n 1.8 250n 1.8 250.01n 0 260n 0 260.01n 1.8 290n 1.8 290.01n 0 320n 0 320.01n 1.8 350n 1.8 350.01n 0 360n 0 360.01n 1.8 370n 1.8 370.01n 0 400n 0 400.01n 1.8 430n 1.8 430.01n 0 470n 0 470.01n 1.8 480n 1.8 480.01n 0 490n 0 490.01n 1.8 530n 1.8 530.01n 0 550n 0 550.01n 1.8 570n 1.8 570.01n 0 610n 0 610.01n 1.8 630n 1.8 630.01n 0 ]
* alter @v31[pwl] = [ 0 1.8 10n 1.8 10.01n 0 30n 0 30.01n 1.8 60n 1.8 60.01n 0 70n 0 70.01n 1.8 80n 1.8 80.01n 0 120n 0 120.01n 1.8 140n 1.8 140.01n 0 160n 0 160.01n 1.8 180n 1.8 180.01n 0 190n 0 190.01n 1.8 210n 1.8 210.01n 0 260n 0 260.01n 1.8 270n 1.8 270.01n 0 280n 0 280.01n 1.8 290n 1.8 290.01n 0 310n 0 310.01n 1.8 320n 1.8 320.01n 0 350n 0 350.01n 1.8 370n 1.8 370.01n 0 380n 0 380.01n 1.8 390n 1.8 390.01n 0 400n 0 400.01n 1.8 430n 1.8 430.01n 0 440n 0 440.01n 1.8 450n 1.8 450.01n 0 470n 0 470.01n 1.8 500n 1.8 500.01n 0 510n 0 510.01n 1.8 550n 1.8 550.01n 0 560n 0 560.01n 1.8 580n 1.8 580.01n 0 590n 0 590.01n 1.8 610n 1.8 610.01n 0 ]
* alter @v32[pwl] = [ 0 1.8 20n 1.8 20.01n 0 40n 0 40.01n 1.8 60n 1.8 60.01n 0 70n 0 70.01n 1.8 90n 1.8 90.01n 0 110n 0 110.01n 1.8 150n 1.8 150.01n 0 160n 0 160.01n 1.8 180n 1.8 180.01n 0 200n 0 200.01n 1.8 210n 1.8 210.01n 0 220n 0 220.01n 1.8 230n 1.8 230.01n 0 250n 0 250.01n 1.8 260n 1.8 260.01n 0 280n 0 280.01n 1.8 310n 1.8 310.01n 0 320n 0 320.01n 1.8 350n 1.8 350.01n 0 380n 0 380.01n 1.8 390n 1.8 390.01n 0 410n 0 410.01n 1.8 440n 1.8 440.01n 0 460n 0 460.01n 1.8 470n 1.8 470.01n 0 490n 0 490.01n 1.8 510n 1.8 510.01n 0 520n 0 520.01n 1.8 530n 1.8 530.01n 0 540n 0 540.01n 1.8 550n 1.8 550.01n 0 570n 0 570.01n 1.8 580n 1.8 580.01n 0 620n 0 620.01n 1.8 ]
* alter @v33[pwl] = [ 0 0 10n 0 10.01n 1.8 20n 1.8 20.01n 0 40n 0 40.01n 1.8 60n 1.8 60.01n 0 70n 0 70.01n 1.8 100n 1.8 100.01n 0 130n 0 130.01n 1.8 140n 1.8 140.01n 0 160n 0 160.01n 1.8 170n 1.8 170.01n 0 180n 0 180.01n 1.8 220n 1.8 220.01n 0 230n 0 230.01n 1.8 270n 1.8 270.01n 0 290n 0 290.01n 1.8 300n 1.8 300.01n 0 320n 0 320.01n 1.8 360n 1.8 360.01n 0 380n 0 380.01n 1.8 390n 1.8 390.01n 0 420n 0 420.01n 1.8 480n 1.8 480.01n 0 500n 0 500.01n 1.8 510n 1.8 510.01n 0 520n 0 520.01n 1.8 550n 1.8 550.01n 0 560n 0 560.01n 1.8 570n 1.8 570.01n 0 630n 0 630.01n 1.8 ]
* alter @v34[pwl] = [ 0 1.8 40n 1.8 40.01n 0 50n 0 50.01n 1.8 60n 1.8 60.01n 0 70n 0 70.01n 1.8 100n 1.8 100.01n 0 150n 0 150.01n 1.8 180n 1.8 180.01n 0 190n 0 190.01n 1.8 220n 1.8 220.01n 0 240n 0 240.01n 1.8 260n 1.8 260.01n 0 270n 0 270.01n 1.8 280n 1.8 280.01n 0 300n 0 300.01n 1.8 320n 1.8 320.01n 0 330n 0 330.01n 1.8 340n 1.8 340.01n 0 360n 0 360.01n 1.8 380n 1.8 380.01n 0 390n 0 390.01n 1.8 420n 1.8 420.01n 0 430n 0 430.01n 1.8 470n 1.8 470.01n 0 490n 0 490.01n 1.8 510n 1.8 510.01n 0 530n 0 530.01n 1.8 560n 1.8 560.01n 0 580n 0 580.01n 1.8 ]
* alter @v35[pwl] = [ 0 1.8 30n 1.8 30.01n 0 50n 0 50.01n 1.8 60n 1.8 60.01n 0 70n 0 70.01n 1.8 80n 1.8 80.01n 0 100n 0 100.01n 1.8 110n 1.8 110.01n 0 130n 0 130.01n 1.8 160n 1.8 160.01n 0 190n 0 190.01n 1.8 200n 1.8 200.01n 0 220n 0 220.01n 1.8 250n 1.8 250.01n 0 260n 0 260.01n 1.8 300n 1.8 300.01n 0 340n 0 340.01n 1.8 360n 1.8 360.01n 0 380n 0 380.01n 1.8 390n 1.8 390.01n 0 410n 0 410.01n 1.8 440n 1.8 440.01n 0 460n 0 460.01n 1.8 480n 1.8 480.01n 0 500n 0 500.01n 1.8 510n 1.8 510.01n 0 520n 0 520.01n 1.8 530n 1.8 530.01n 0 560n 0 560.01n 1.8 590n 1.8 590.01n 0 630n 0 630.01n 1.8 ]
* alter @v36[pwl] = [ 0 0 10n 0 10.01n 1.8 20n 1.8 20.01n 0 30n 0 30.01n 1.8 50n 1.8 50.01n 0 70n 0 70.01n 1.8 150n 1.8 150.01n 0 170n 0 170.01n 1.8 180n 1.8 180.01n 0 190n 0 190.01n 1.8 200n 1.8 200.01n 0 210n 0 210.01n 1.8 250n 1.8 250.01n 0 270n 0 270.01n 1.8 300n 1.8 300.01n 0 330n 0 330.01n 1.8 340n 1.8 340.01n 0 350n 0 350.01n 1.8 370n 1.8 370.01n 0 380n 0 380.01n 1.8 410n 1.8 410.01n 0 430n 0 430.01n 1.8 450n 1.8 450.01n 0 470n 0 470.01n 1.8 480n 1.8 480.01n 0 510n 0 510.01n 1.8 530n 1.8 530.01n 0 550n 0 550.01n 1.8 580n 1.8 580.01n 0 590n 0 590.01n 1.8 600n 1.8 600.01n 0 610n 0 610.01n 1.8 620n 1.8 620.01n 0 ]
* alter @v37[pwl] = [ 0 1.8 10n 1.8 10.01n 0 80n 0 80.01n 1.8 90n 1.8 90.01n 0 110n 0 110.01n 1.8 130n 1.8 130.01n 0 150n 0 150.01n 1.8 170n 1.8 170.01n 0 200n 0 200.01n 1.8 230n 1.8 230.01n 0 250n 0 250.01n 1.8 270n 1.8 270.01n 0 290n 0 290.01n 1.8 300n 1.8 300.01n 0 310n 0 310.01n 1.8 320n 1.8 320.01n 0 340n 0 340.01n 1.8 370n 1.8 370.01n 0 380n 0 380.01n 1.8 390n 1.8 390.01n 0 400n 0 400.01n 1.8 410n 1.8 410.01n 0 420n 0 420.01n 1.8 430n 1.8 430.01n 0 440n 0 440.01n 1.8 480n 1.8 480.01n 0 490n 0 490.01n 1.8 500n 1.8 500.01n 0 510n 0 510.01n 1.8 530n 1.8 530.01n 0 540n 0 540.01n 1.8 560n 1.8 560.01n 0 580n 0 580.01n 1.8 ]
* alter @v38[pwl] = [ 0 0 20n 0 20.01n 1.8 40n 1.8 40.01n 0 50n 0 50.01n 1.8 60n 1.8 60.01n 0 110n 0 110.01n 1.8 130n 1.8 130.01n 0 170n 0 170.01n 1.8 180n 1.8 180.01n 0 270n 0 270.01n 1.8 280n 1.8 280.01n 0 300n 0 300.01n 1.8 330n 1.8 330.01n 0 340n 0 340.01n 1.8 360n 1.8 360.01n 0 370n 0 370.01n 1.8 380n 1.8 380.01n 0 390n 0 390.01n 1.8 400n 1.8 400.01n 0 420n 0 420.01n 1.8 440n 1.8 440.01n 0 450n 0 450.01n 1.8 460n 1.8 460.01n 0 470n 0 470.01n 1.8 480n 1.8 480.01n 0 560n 0 560.01n 1.8 580n 1.8 580.01n 0 590n 0 590.01n 1.8 610n 1.8 610.01n 0 ]
* alter @v39[pwl] = [ 0 0 10n 0 10.01n 1.8 20n 1.8 20.01n 0 40n 0 40.01n 1.8 60n 1.8 60.01n 0 70n 0 70.01n 1.8 90n 1.8 90.01n 0 100n 0 100.01n 1.8 120n 1.8 120.01n 0 140n 0 140.01n 1.8 150n 1.8 150.01n 0 180n 0 180.01n 1.8 270n 1.8 270.01n 0 280n 0 280.01n 1.8 310n 1.8 310.01n 0 320n 0 320.01n 1.8 330n 1.8 330.01n 0 340n 0 340.01n 1.8 350n 1.8 350.01n 0 360n 0 360.01n 1.8 390n 1.8 390.01n 0 400n 0 400.01n 1.8 430n 1.8 430.01n 0 460n 0 460.01n 1.8 500n 1.8 500.01n 0 530n 0 530.01n 1.8 540n 1.8 540.01n 0 560n 0 560.01n 1.8 610n 1.8 610.01n 0 630n 0 630.01n 1.8 ]
* alter @v40[pwl] = [ 0 0 10n 0 10.01n 1.8 20n 1.8 20.01n 0 30n 0 30.01n 1.8 40n 1.8 40.01n 0 50n 0 50.01n 1.8 90n 1.8 90.01n 0 140n 0 140.01n 1.8 180n 1.8 180.01n 0 190n 0 190.01n 1.8 220n 1.8 220.01n 0 230n 0 230.01n 1.8 250n 1.8 250.01n 0 260n 0 260.01n 1.8 270n 1.8 270.01n 0 290n 0 290.01n 1.8 300n 1.8 300.01n 0 320n 0 320.01n 1.8 350n 1.8 350.01n 0 360n 0 360.01n 1.8 390n 1.8 390.01n 0 400n 0 400.01n 1.8 470n 1.8 470.01n 0 480n 0 480.01n 1.8 510n 1.8 510.01n 0 550n 0 550.01n 1.8 590n 1.8 590.01n 0 600n 0 600.01n 1.8 ]
* alter @v41[pwl] = [ 0 0 10n 0 10.01n 1.8 50n 1.8 50.01n 0 80n 0 80.01n 1.8 110n 1.8 110.01n 0 140n 0 140.01n 1.8 150n 1.8 150.01n 0 160n 0 160.01n 1.8 200n 1.8 200.01n 0 210n 0 210.01n 1.8 220n 1.8 220.01n 0 250n 0 250.01n 1.8 280n 1.8 280.01n 0 290n 0 290.01n 1.8 310n 1.8 310.01n 0 340n 0 340.01n 1.8 400n 1.8 400.01n 0 410n 0 410.01n 1.8 430n 1.8 430.01n 0 440n 0 440.01n 1.8 450n 1.8 450.01n 0 470n 0 470.01n 1.8 490n 1.8 490.01n 0 520n 0 520.01n 1.8 550n 1.8 550.01n 0 590n 0 590.01n 1.8 620n 1.8 620.01n 0 ]
* tran 1n 640n
* rspice-control-end
.end
