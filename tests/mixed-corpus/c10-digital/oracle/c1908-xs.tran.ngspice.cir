* C10 c1908, tran: O1 (ngspice-46) oracle deck. The ISCAS85 transistor-level deck
* tests/iscas85/85/c1908/c1908.net (45 nm BSIM4 PTM, Vdd 1.8 V, .tran 1ps 1ns) included verbatim,
* plus the RSpice decks' strobe and XSPICE A/D probes at 0.9 V (Vdd/2) on the
* primary outputs, named as the xs digital nets. The control script swings every
* input 0 -> 1.8 V (the deck's own 0 -> 1 V inputs, a logic 1 for the gate-level
* renderings' 0.5 V threshold, do not resolve every 1.8 V gate: c880's all-high
* response differs) with the deck's timing, and its run is the one written.
.include ../../../iscas85/85/c1908/c1908.net
.include ../net/strobe_iscas.cir
aprobe [g1884 g1885 g1886 g1887 g1888 g1889 g1890 g1891 g1892 g1893 g1894 g1895 g1896 g1897 g1898
+ g1899 g1900 g1901 g1902 g1903 g1904 g1905 g1906 g1907 g1908] [d_g1884 d_g1885 d_g1886 d_g1887
+ d_g1888 d_g1889 d_g1890 d_g1891 d_g1892 d_g1893 d_g1894 d_g1895 d_g1896 d_g1897 d_g1898 d_g1899
+ d_g1900 d_g1901 d_g1902 d_g1903 d_g1904 d_g1905 d_g1906 d_g1907 d_g1908] adc_logic
.model adc_logic adc_bridge(in_low = 0.9 in_high = 0.9 rise_delay = 1e-12 fall_delay = 1e-12)
* rspice-write: v(g1884)
* rspice-events: d_stb d_g1884 d_g1885 d_g1886 d_g1887 d_g1888 d_g1889 d_g1890 d_g1891 d_g1892 d_g1893 d_g1894 d_g1895 d_g1896 d_g1897 d_g1898 d_g1899 d_g1900 d_g1901 d_g1902 d_g1903 d_g1904 d_g1905 d_g1906 d_g1907 d_g1908
* rspice-control-begin
* alter @v1[pulse] = [ 0 1.8 0 200p 200p 1n 2n ]
* alter @v2[pulse] = [ 0 1.8 0 200p 200p 1n 2n ]
* alter @v3[pulse] = [ 0 1.8 0 200p 200p 1n 2n ]
* alter @v4[pulse] = [ 0 1.8 0 200p 200p 1n 2n ]
* alter @v5[pulse] = [ 0 1.8 0 200p 200p 1n 2n ]
* alter @v6[pulse] = [ 0 1.8 0 200p 200p 1n 2n ]
* alter @v7[pulse] = [ 0 1.8 0 200p 200p 1n 2n ]
* alter @v8[pulse] = [ 0 1.8 0 200p 200p 1n 2n ]
* alter @v9[pulse] = [ 0 1.8 0 200p 200p 1n 2n ]
* alter @v10[pulse] = [ 0 1.8 0 200p 200p 1n 2n ]
* alter @v11[pulse] = [ 0 1.8 0 200p 200p 1n 2n ]
* alter @v12[pulse] = [ 0 1.8 0 200p 200p 1n 2n ]
* alter @v13[pulse] = [ 0 1.8 0 200p 200p 1n 2n ]
* alter @v14[pulse] = [ 0 1.8 0 200p 200p 1n 2n ]
* alter @v15[pulse] = [ 0 1.8 0 200p 200p 1n 2n ]
* alter @v16[pulse] = [ 0 1.8 0 200p 200p 1n 2n ]
* alter @v17[pulse] = [ 0 1.8 0 200p 200p 1n 2n ]
* alter @v18[pulse] = [ 0 1.8 0 200p 200p 1n 2n ]
* alter @v19[pulse] = [ 0 1.8 0 200p 200p 1n 2n ]
* alter @v20[pulse] = [ 0 1.8 0 200p 200p 1n 2n ]
* alter @v21[pulse] = [ 0 1.8 0 200p 200p 1n 2n ]
* alter @v22[pulse] = [ 0 1.8 0 200p 200p 1n 2n ]
* alter @v23[pulse] = [ 0 1.8 0 200p 200p 1n 2n ]
* alter @v24[pulse] = [ 0 1.8 0 200p 200p 1n 2n ]
* alter @v25[pulse] = [ 0 1.8 0 200p 200p 1n 2n ]
* alter @v26[pulse] = [ 0 1.8 0 200p 200p 1n 2n ]
* alter @v27[pulse] = [ 0 1.8 0 200p 200p 1n 2n ]
* alter @v28[pulse] = [ 0 1.8 0 200p 200p 1n 2n ]
* alter @v29[pulse] = [ 0 1.8 0 200p 200p 1n 2n ]
* alter @v30[pulse] = [ 0 1.8 0 200p 200p 1n 2n ]
* alter @v31[pulse] = [ 0 1.8 0 200p 200p 1n 2n ]
* alter @v32[pulse] = [ 0 1.8 0 200p 200p 1n 2n ]
* alter @v33[pulse] = [ 0 1.8 0 200p 200p 1n 2n ]
* run
* rspice-control-end
.end
