* C10 c499, tran: O1 (ngspice-46) oracle deck. The ISCAS85 transistor-level deck
* tests/iscas85/85/c499/c499.net (45 nm BSIM4 PTM, Vdd 1.8 V, .tran 1ps 1ns) included verbatim,
* plus the RSpice decks' strobe and XSPICE A/D probes at 0.9 V (Vdd/2) on the
* primary outputs, named as the xs digital nets. The control script swings every
* input 0 -> 1.8 V (the deck's own 0 -> 1 V inputs, a logic 1 for the gate-level
* renderings' 0.5 V threshold, do not resolve every 1.8 V gate: c880's all-high
* response differs) with the deck's timing, and its run is the one written.
.include ../../../iscas85/85/c499/c499.net
.include ../net/strobe_iscas.cir
aprobe [g468 g469 g470 g471 g472 g473 g474 g475 g476 g477 g478 g479 g480 g481 g482 g483 g484 g485
+ g486 g487 g488 g489 g490 g491 g492 g493 g494 g495 g496 g497 g498 g499] [d_g468 d_g469 d_g470
+ d_g471 d_g472 d_g473 d_g474 d_g475 d_g476 d_g477 d_g478 d_g479 d_g480 d_g481 d_g482 d_g483 d_g484
+ d_g485 d_g486 d_g487 d_g488 d_g489 d_g490 d_g491 d_g492 d_g493 d_g494 d_g495 d_g496 d_g497 d_g498
+ d_g499] adc_logic
.model adc_logic adc_bridge(in_low = 0.9 in_high = 0.9 rise_delay = 1e-12 fall_delay = 1e-12)
* rspice-write: v(g468)
* rspice-events: d_stb d_g468 d_g469 d_g470 d_g471 d_g472 d_g473 d_g474 d_g475 d_g476 d_g477 d_g478 d_g479 d_g480 d_g481 d_g482 d_g483 d_g484 d_g485 d_g486 d_g487 d_g488 d_g489 d_g490 d_g491 d_g492 d_g493 d_g494 d_g495 d_g496 d_g497 d_g498 d_g499
* rspice-control-begin
* alter @v1[pulse] = [ 0 1.8 0 200p 200p 1n 2n ]
* alter @v2[pulse] = [ 0 1.8 0 200p 200p 1n 2n ]
* alter @v3[pulse] = [ 0 1.8 0 200p 200p 1n 2n ]
* alter @v4[pulse] = [ 0 1.8 0 200p 200p 1n 2n ]
* alter @v5[pulse] = [ 0 1.8 0 200p 200p 1n 2n ]
* alter @v6[pulse] = [ 0 1.8 0 200p 200p 1n 2n ]
* alter @v7[pulse] = [ 0 1.8 0 200p 200p 1n 2n ]
* alter @v8[pulse] = [ 0 1.8 0 200p 200p 1n 2n ]
* alter @v9[pulse] = [ 0 1.8 0 200p 200p 1n 2n ]
* alter @v10[pulse] = [ 0 1.8 0 200p 200p 1n 2n ]
* alter @v11[pulse] = [ 0 1.8 0 200p 200p 1n 2n ]
* alter @v12[pulse] = [ 0 1.8 0 200p 200p 1n 2n ]
* alter @v13[pulse] = [ 0 1.8 0 200p 200p 1n 2n ]
* alter @v14[pulse] = [ 0 1.8 0 200p 200p 1n 2n ]
* alter @v15[pulse] = [ 0 1.8 0 200p 200p 1n 2n ]
* alter @v16[pulse] = [ 0 1.8 0 200p 200p 1n 2n ]
* alter @v17[pulse] = [ 0 1.8 0 200p 200p 1n 2n ]
* alter @v18[pulse] = [ 0 1.8 0 200p 200p 1n 2n ]
* alter @v19[pulse] = [ 0 1.8 0 200p 200p 1n 2n ]
* alter @v20[pulse] = [ 0 1.8 0 200p 200p 1n 2n ]
* alter @v21[pulse] = [ 0 1.8 0 200p 200p 1n 2n ]
* alter @v22[pulse] = [ 0 1.8 0 200p 200p 1n 2n ]
* alter @v23[pulse] = [ 0 1.8 0 200p 200p 1n 2n ]
* alter @v24[pulse] = [ 0 1.8 0 200p 200p 1n 2n ]
* alter @v25[pulse] = [ 0 1.8 0 200p 200p 1n 2n ]
* alter @v26[pulse] = [ 0 1.8 0 200p 200p 1n 2n ]
* alter @v27[pulse] = [ 0 1.8 0 200p 200p 1n 2n ]
* alter @v28[pulse] = [ 0 1.8 0 200p 200p 1n 2n ]
* alter @v29[pulse] = [ 0 1.8 0 200p 200p 1n 2n ]
* alter @v30[pulse] = [ 0 1.8 0 200p 200p 1n 2n ]
* alter @v31[pulse] = [ 0 1.8 0 200p 200p 1n 2n ]
* alter @v32[pulse] = [ 0 1.8 0 200p 200p 1n 2n ]
* alter @v33[pulse] = [ 0 1.8 0 200p 200p 1n 2n ]
* alter @v34[pulse] = [ 0 1.8 0 200p 200p 1n 2n ]
* alter @v35[pulse] = [ 0 1.8 0 200p 200p 1n 2n ]
* alter @v36[pulse] = [ 0 1.8 0 200p 200p 1n 2n ]
* alter @v37[pulse] = [ 0 1.8 0 200p 200p 1n 2n ]
* alter @v38[pulse] = [ 0 1.8 0 200p 200p 1n 2n ]
* alter @v39[pulse] = [ 0 1.8 0 200p 200p 1n 2n ]
* alter @v40[pulse] = [ 0 1.8 0 200p 200p 1n 2n ]
* alter @v41[pulse] = [ 0 1.8 0 200p 200p 1n 2n ]
* run
* rspice-control-end
.end
