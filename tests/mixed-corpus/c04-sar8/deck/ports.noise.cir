* C4 8-bit SAR ADC, variant ports, noise (comparator, code held at the D-A state)
.hdl "../net/sar8.v"
.hdl "../net/cmp_va.va"
.include ../net/caps_nominal.cir
.include ../net/sar_analog.cir
.include ../net/vin_codes.cir
.include ../net/sar_ports.cir
.param vcc=1.8
.noise v(xcmp.o1) vcref dec 10 1k 10meg
.end
