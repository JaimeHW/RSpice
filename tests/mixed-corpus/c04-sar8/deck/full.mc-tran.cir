* C4 8-bit SAR ADC, variant full, mc-tran (DNL at the major carry)
.hdl "../net/sar8_full.v" module=tb_sar
.hdl "../net/sar8_full.v" module=sar8
.hdl "../net/cmp_va.va"
.include ../net/caps_mc.cir
.include ../net/sar_analog.cir
.include ../net/vin_ramp.cir
.include ../net/sar_full.cir
.param vcc=1.8 nconv=16
* DNL probe: 1 V while eoc is high on a conversion that produced code 127
bis127 is127 0 v = v(eoc)>0.9 ? (abs(v(code)-127)<0.5 ? 1 : 0) : 0
.mc 10 seed 3
.tran 10n 16.6u
.end
