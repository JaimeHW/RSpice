// C6 p3: buck_ctrl.vams's controller with an authored, supply-aware gate-drive
// connect module (RSpice-authored). The D/A drives the gate to the level of
// its supply port `vsup`, read live, behind 20 ohm with a 1 ns transition();
// the connect statement wires the port to the vdrv net.
`include "disciplines.vams"
`timescale 1ps/1ps
module buck_ctrl(fb, hs, ls);
  input fb;
  electrical fb;
  output hs, ls;
  reg hs, ls;
  parameter integer TICK = 31250;
  parameter integer RAMP = 16;
  parameter integer TARGET = 922;
  integer ref, code, acc, duty, d, dfr, carry;
  initial begin
    hs = 1'b0;
    ls = 1'b0;
    ref = 0;
    code = 0;
    acc = 0;
    duty = 0;
    d = 1;
    dfr = 0;
    carry = 0;
  end
  always begin
    #(TICK);
    code = V(fb) * 512.0;
    if (code < 0) code = 0;
    if (code > 1023) code = 1023;
    ref = ref + RAMP;
    if (ref > TARGET) ref = TARGET;
    acc = acc + ref - code;
    if (acc < 0) acc = 0;
    if (acc > 65535) acc = 65535;
    duty = acc / 64;
    dfr = dfr + duty % 16;
    carry = 0;
    if (dfr >= 16) begin
      dfr = dfr - 16;
      carry = 1;
    end
    d = duty / 16 + carry;
    if (d < 1) d = 1;
    if (d > 58) d = 58;
    #(TICK) hs = 1'b1;
    #(d * TICK) hs = 1'b0;
    #(2 * TICK) ls = 1'b1;
    #((60 - d) * TICK) ls = 1'b0;
  end
endmodule

connectmodule gate_drive(d, a, vsup);
  input d;
  logic d;
  output a;
  electrical a;
  inout vsup;
  electrical vsup;
  analog I(a) <+ (V(a) - transition(d ? V(vsup) : 0.0, 0, 1n, 1n)) / 20.0;
endmodule

connectrules gate_rules;
  connect gate_drive #(.vsup(vdrv));
endconnectrules
