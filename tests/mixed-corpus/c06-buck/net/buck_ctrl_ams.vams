// C6 vams: the buck controller of buck_ctrl.vams with a Verilog-AMS sampling
// ADC (RSpice-authored). The analog block samples V(fb) on a 2 us timer at
// each period start (tick 0); an always block flags over-voltage on an
// absdelta event (VAMS-2023 5.10.3.4 allows absdelta only in initial and
// always blocks). The digital process reads the sample at tick 1 (race-free)
// and cuts the duty to one tick while the flag is set. Everything else is
// buck_ctrl.vams.
`include "disciplines.vams"
`timescale 1ps/1ps
module buck_ctrl(fb, hs, ls);
  input fb;
  electrical fb;
  output hs, ls;
  reg hs, ls;
  parameter integer TICK = 31250;
  parameter integer RAMP = 16;
  parameter integer TARGET = 922;
  integer ref, code, acc, duty, d, dfr, carry;
  real vs, ov;
  analog begin
    @(timer(0, 2e-6)) vs = V(fb);
  end
  always @(absdelta(V(fb), 0.05)) ov = (V(fb) > 2.2) ? 1.0 : 0.0;
  initial begin
    hs = 1'b0;
    ls = 1'b0;
    ref = 0;
    code = 0;
    acc = 0;
    duty = 0;
    d = 1;
    dfr = 0;
    carry = 0;
  end
  always begin
    #(TICK);
    code = vs * 512.0;
    if (code < 0) code = 0;
    if (code > 1023) code = 1023;
    ref = ref + RAMP;
    if (ref > TARGET) ref = TARGET;
    acc = acc + ref - code;
    if (acc < 0) acc = 0;
    if (acc > 65535) acc = 65535;
    duty = acc / 64;
    dfr = dfr + duty % 16;
    carry = 0;
    if (dfr >= 16) begin
      dfr = dfr - 16;
      carry = 1;
    end
    d = duty / 16 + carry;
    if (d < 1) d = 1;
    if (d > 58) d = 58;
    if (ov > 0.5) d = 1;
    #(TICK) hs = 1'b1;
    #(d * TICK) hs = 1'b0;
    #(2 * TICK) ls = 1'b1;
    #((60 - d) * TICK) ls = 1'b0;
  end
endmodule
