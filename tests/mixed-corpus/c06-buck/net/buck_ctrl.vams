// C6 vdig: digital controller of the buck converter (RSpice-authored).
// One 2 us switching period is 64 ticks of 31.25 ns. Each period:
//   tick 1   sample V(fb): code = V(fb)·512 (10 bits over 0..2 V);
//            soft start: ref steps by RAMP toward TARGET (922 = 1.80078 V);
//            integral control: acc += ref − code, duty = acc/64 (10 bits);
//            a 4-bit first-order sigma-delta dithers duty onto 6-bit ticks:
//            d = duty[9:4] + carry, clamped to 1..58;
//   tick 2   hs rises; tick 2+d hs falls;
//   tick 4+d ls rises (2 ticks dead time); tick 64 ls falls (2 ticks again).
// The period is scheduled with delays rather than a free-running 32 MHz
// clock, so the digital work is a handful of events per period; the tick
// timing is the same. hs and ls reach the switch controls through the
// built-in D/A converters at vcc.
`include "disciplines.vams"
`timescale 1ps/1ps
module buck_ctrl(fb, hs, ls);
  input fb;
  electrical fb;
  output hs, ls;
  reg hs, ls;
  parameter integer TICK = 31250;
  parameter integer RAMP = 16;
  parameter integer TARGET = 922;
  integer ref, code, acc, duty, d, dfr, carry;
  initial begin
    hs = 1'b0;
    ls = 1'b0;
    ref = 0;
    code = 0;
    acc = 0;
    duty = 0;
    d = 1;
    dfr = 0;
    carry = 0;
  end
  always begin
    #(TICK);
    code = V(fb) * 512.0;
    if (code < 0) code = 0;
    if (code > 1023) code = 1023;
    ref = ref + RAMP;
    if (ref > TARGET) ref = TARGET;
    acc = acc + ref - code;
    if (acc < 0) acc = 0;
    if (acc > 65535) acc = 65535;
    duty = acc / 64;
    dfr = dfr + duty % 16;
    carry = 0;
    if (dfr >= 16) begin
      dfr = dfr - 16;
      carry = 1;
    end
    d = duty / 16 + carry;
    if (d < 1) d = 1;
    if (d > 58) d = 58;
    #(TICK) hs = 1'b1;
    #(d * TICK) hs = 1'b0;
    #(2 * TICK) ls = 1'b1;
    #((60 - d) * TICK) ls = 1'b0;
  end
endmodule
