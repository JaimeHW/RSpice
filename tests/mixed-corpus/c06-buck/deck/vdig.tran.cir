* C6 digitally controlled buck converter, variant vdig, tran
* Soft start to 1.8 V by ~400 us, load step 2 -> 1 ohm at 500 us. The design's
* 3 ms (922-period soft start) is compressed: the reference ramps 16 codes per
* period, so the case runs in seconds.
.param lv=22u cv=4.7u
.hdl "../net/buck_ctrl.vams"
.include ../net/stage.cir
xctrl vout ghs gls buck_ctrl
* The cell reads the gate drives on their converters' endpoints, which a run
* records only when named: ghs and gls carry the same bits.
.esave xctrl.hs__event_0 xctrl.ls__event_0
.tran 50n 0.8m
.end
