* C6 digitally controlled buck converter, variant vams (timer/absdelta ADC), tran
.param lv=22u cv=4.7u
.hdl "../net/buck_ctrl_ams.vams"
.include ../net/stage.cir
xctrl vout ghs gls buck_ctrl
* The cell reads the gate drives on their converters' endpoints, which a run
* records only when named: ghs and gls carry the same bits.
.esave xctrl.hs__event_0 xctrl.ls__event_0
.tran 50n 0.8m
.end
