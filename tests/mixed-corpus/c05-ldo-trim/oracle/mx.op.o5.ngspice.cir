* C5 LDO, variant mx, op: O5-O1 (ngspice-46) held-digital oracle deck
* The O5 circuit (oracle/mx.o5.cir) with the trim bits held at code 0 behind 20 ohm.
* The ESD junction is ngspice's JUNCAP200 OSDI build with the same AB/LS/LG.
.include ../net/models-bsim4.cir
.include ../net/ldo_body.inc
.include ../net/ldo.cir
njesd 0 vout jc200 ab=1e-9 ls=1.3e-4 lg=0
.model jc200 juncap200
vtr3 tr3_h 0 0
rtr3 tr3_h tr3 20
vtr2 tr2_h 0 0
rtr2 tr2_h tr2 20
vtr1 tr1_h 0 0
rtr1 tr1_h tr1 20
vtr0 tr0_h 0 0
rtr0 tr0_h tr0 20
.op
.save v(vout) v(og) v(fb) i(vin)
* rspice-control-begin
* pre_osdi {ngspice_lib}/juncap200.osdi
* run
* rspice-control-end
.end
