* C5 LDO, trim code 15 twin, ac: O5-O1 (ngspice-46) held-digital oracle deck
* The O5 circuit at code 15 (oracle/mx.o5-c15.cir), each closed trim switch
* stated as its 10 ohm on-resistance. ngspice-46 stamps a voltage-controlled
* switch in ac with the state it held before the operating point, not the one
* the operating point closed it in (sw/swload.c: MODEINITSMSIG takes
* CKTstate1), so with the bits at vcc its ac sees all four switches open. The
* deck holds the bits at 0 V instead, which opens every switch (roff 1e12) in
* every analysis, and puts 10 ohm across each trimmed resistor, where a closed
* switch puts its ron: 10 ohm in parallel with 1e12, the closed switch to 1e-11.
* The ESD junction is ngspice's JUNCAP200 OSDI build with the same AB/LS/LG.
.include ../net/models-bsim4.cir
.include ../net/ldo_body.inc
.include ../net/ldo.cir
njesd 0 vout jc200 ab=1e-9 ls=1.3e-4 lg=0
.model jc200 juncap200
vtr3 tr3_h 0 0
rtr3 tr3_h tr3 20
vtr2 tr2_h 0 0
rtr2 tr2_h tr2 20
vtr1 tr1_h 0 0
rtr1 tr1_h tr1 20
vtr0 tr0_h 0 0
rtr0 tr0_h tr0 20
ron3 l1 l2 10
ron2 l2 l3 10
ron1 l3 l4 10
ron0 l4 0 10
.ac dec 10 10 100meg
.save v(vout)
* rspice-control-begin
* pre_osdi {ngspice_lib}/juncap200.osdi
* run
* rspice-control-end
.end
