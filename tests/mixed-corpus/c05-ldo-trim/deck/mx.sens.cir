* C5 LDO with a serially loaded trim DAC, variant mx, sens
.include ../net/models-bsim4.cir
.include ../net/ldo_body.inc
.include ../net/ldo.cir
.include ../net/esd.cir
.include ../net/spi.cir
.hdl "../net/spi_trim.v"
.sens v(vout)
.end
