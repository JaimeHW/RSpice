* C5 LDO with a serially loaded trim DAC, variant mx, tran
.include ../net/models-bsim4.cir
.include ../net/ldo_body.inc
.include ../net/ldo.cir
.include ../net/esd.cir
.include ../net/spi.cir
.hdl "../net/spi_trim.v"
.tran 0.1u 600u 0 0.5u
.end
