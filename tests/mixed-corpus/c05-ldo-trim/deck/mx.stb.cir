* C5 LDO with a serially loaded trim DAC, variant mx, stb
.include ../net/models-bsim4.cir
.include ../net/ldo_body.inc
.include ../net/ldo.cir
.include ../net/esd.cir
.include ../net/spi.cir
.hdl "../net/spi_trim.v"
.stb dec 10 10 100meg probe=vprobe
.end
