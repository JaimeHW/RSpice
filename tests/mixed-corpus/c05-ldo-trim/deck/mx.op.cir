* C5 LDO with a serially loaded trim DAC, variant mx, op
.include ../net/models-bsim4.cir
.include ../net/ldo_body.inc
.include ../net/ldo.cir
.include ../net/esd.cir
.include ../net/spi.cir
.hdl "../net/spi_trim.v"
.op
* The pass device's drop: vds, signed for its type as ngspice reports it (a
* PMOS reads vs - vd), at most 0.6 V. It is 0.649 V, so the check fails.
.ASSERT mpsat DEV=mp PARAM=vds MAX=0.6
.end
