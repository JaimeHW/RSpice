* C5 LDO with a serially loaded trim DAC, variant mx, dc-line
.include ../net/models-bsim4.cir
.include ../net/ldo_body.inc
.include ../net/ldo.cir
.include ../net/esd.cir
.include ../net/spi.cir
.hdl "../net/spi_trim.v"
.dc vin 1.4 2.0 0.02
.end
