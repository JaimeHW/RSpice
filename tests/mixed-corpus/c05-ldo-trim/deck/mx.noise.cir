* C5 LDO with a serially loaded trim DAC, variant mx, noise
.include ../net/models-bsim4.cir
.include ../net/ldo_body.inc
.include ../net/ldo.cir
.include ../net/esd.cir
.include ../net/spi.cir
.hdl "../net/spi_trim.v"
.noise v(vout) vref dec 10 10 10meg
.end
