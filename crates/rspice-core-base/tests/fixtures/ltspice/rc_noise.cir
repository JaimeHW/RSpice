* rc noise
V1 in 0 0 AC 1
R1 in out 1k
C1 out 0 1n
.noise V(out) V1 dec 10 1 1meg
.end
