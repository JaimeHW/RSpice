* rc low-pass ac
V1 in 0 AC 1
R1 in out 1k
C1 out 0 1n
.ac dec 20 1 1meg
.end
