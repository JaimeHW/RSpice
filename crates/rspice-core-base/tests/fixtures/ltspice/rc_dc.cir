* resistor divider dc sweep
V1 in 0 0
R1 in out 1k
R2 out 0 3k
.dc V1 0 5 0.25
.end
