* rc divider op
V1 in 0 5
R1 in out 1k
R2 out 0 3k
C1 out 0 1n
.op
.end
