* rc transient fastaccess
V1 in 0 PULSE(0 1 0 1p 1p 1 2)
R1 in out 1k
C1 out 0 1n
.options plotwinsize=0 fastaccess
.tran 0 5u 0 20n
.end
