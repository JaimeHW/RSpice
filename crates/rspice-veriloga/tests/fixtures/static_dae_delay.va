module static_delayed(p, n, c);
    inout p, n, c;
    electrical p, n, c;
    analog begin
        I(p,n)<+2.0*V(p,n)+absdelay(V(p,n),0.25)
                +absdelay(V(p,n),V(c,n),0.5)+ddt(3.0*V(p,n));
        if (V(p,n)<0.0) I(p,n)<+sqrt(V(p,n));
    end
endmodule
