* RC Transient Test Circuit
* Time constant = R*C = 1ms

V1 1 0 5
R1 1 2 1k
C1 2 0 1u

.TRAN 10u 5m
.end
