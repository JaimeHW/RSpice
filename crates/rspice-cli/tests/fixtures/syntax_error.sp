* Syntax Error Test - Invalid line for error handling test
* This file intentionally contains errors

V1 1 0 10
R1 1 2 1k
INVALID LINE HERE
R2 2 0 1k

.end
