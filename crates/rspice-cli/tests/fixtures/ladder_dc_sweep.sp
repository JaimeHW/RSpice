* Long ladder DC sweep

V1 in 0 0
R1 in n1 1k
R2 n1 n2 1k
R3 n2 n3 1k
R4 n3 n4 1k
R5 n4 n5 1k
R6 n5 0 1k

.DC V1 0 6 1
.end
