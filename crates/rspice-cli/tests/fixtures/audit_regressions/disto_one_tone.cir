* One-tone Volterra distortion oracle: ideal source clamps diode voltage, so
* its branch current has closed-form Taylor-series harmonic products.
V1 out 0 DC 0.5 DISTOF1 1m 0
D1 out 0 DM
.model DM D(IS=1e-12 N=1 CJO=0 TT=0)
.save I(V1)
.disto lin 3 1k 2k
.end
