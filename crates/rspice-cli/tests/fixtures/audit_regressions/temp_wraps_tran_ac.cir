Temperature axis wraps authored transient and AC analyses
V1 in 0 DC 0.5 AC 1
R1 in out 1k
D1 out 0 DMOD
.MODEL DMOD D(IS=1e-12)
C1 out 0 1n
.TEMP 25 85
.TRAN 0.1u 1u
.AC LIN 2 1k 2k
.SAVE V(out)
.END
