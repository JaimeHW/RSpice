* LC Tank for HB Analysis
* Resonant frequency = 1 GHz
* Q factor ~ 10

* RF signal source at fundamental
Vin in 0 DC 0 SIN(0 1 1G)

* Source resistance
Rs in tank 50

* LC tank: L = 2.53nH, C = 10pF → f0 = 1 GHz
L1 tank 0 2.53n
C1 tank 0 10p

* Parallel loss resistor for Q~10
Rp tank 0 159

.END
