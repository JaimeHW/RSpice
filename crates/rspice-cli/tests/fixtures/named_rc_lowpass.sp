* Named RC lowpass AC test

V1 in 0 AC 1
R1 in out 1k
C1 out 0 1u

.AC DEC 10 1 10k
.end
